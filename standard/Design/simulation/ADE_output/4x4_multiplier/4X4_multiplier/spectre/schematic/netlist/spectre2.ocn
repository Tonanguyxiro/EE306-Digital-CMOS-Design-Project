simulator( 'spectre )
design(	 "/home/SME_VLSI/VLSI_57/simulation/delay/4x4_multiplier/4X4_multiplier/spectre/schematic/netlist/netlist")
resultsDir( "/home/SME_VLSI/VLSI_57/simulation/delay/4x4_multiplier/4X4_multiplier/spectre/schematic" )
modelFile(
    '("/home/SME_VLSI/306cadence/assuraTech/oa_2014/gpdk/../models/gpdk.scs" "NN")
)
analysis('tran ?stop "30n"  )
envOption(
	'analysisOrder  list("tran")
)
temp( 27 )
run()
