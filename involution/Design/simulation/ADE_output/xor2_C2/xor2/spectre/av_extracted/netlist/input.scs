// Generated for: spectre
// Generated on: May 27 03:28:00 2021
// Design library name: multiplier_low
// Design cell name: xor2
// Design view name: av_extracted
simulator lang=spectre
global 0 vdd!
include "/home/SME_VLSI/VLSI_57/306cadence/test_files/2_XOR_C2.input"
include "/home/SME_VLSI/306cadence/assuraTech/oa_2014/gpdk/../models/gpdk.scs" section=NN

// Library name: multiplier_low
// Cell name: xor2
// View name: av_extracted
re1 (\4\:Ai \2\:Ai) resistor r=4.1723 c=0
re2 (\7\:A \1\:A) resistor r=4.652 c=0
re3 (Out \3\:Out) resistor r=5.0851 c=0
rf1 (\1\:A A) resistor r=0.003806 c=0
rf2 (\1\:A \2\:A) resistor r=0.006818 c=0
rf3 (Ai \2\:Ai) resistor r=0.4786 c=0
rf4 (\2\:Ai \3\:Ai) resistor r=0.6211 c=0
rf5 (\5\:Ai \4\:Ai) resistor r=0.09851 c=0
rf6 (\6\:A \7\:A) resistor r=0.007087 c=0
rf7 (\1\:Out \2\:Out) resistor r=0.6277 c=0
rf8 (\2\:Out \3\:Out) resistor r=0.2434 c=0
rf9 (\2\:Out \4\:Out) resistor r=0.4877 c=0
rf10 (\3\:Out \5\:Out) resistor r=0.637 c=0
rf11 (\3\:Out \6\:Out) resistor r=0.4883 c=0
rf12 (\5\:Bi \6\:Bi) resistor r=0.2091 c=0
rf13 (\6\:Bi Bi) resistor r=0.419 c=0
rf14 (\6\:Bi \7\:Bi) resistor r=0.9147 c=0
rf15 (\1\:vdd! vdd!) resistor r=0.4396 c=0
rf16 (vdd! \2\:vdd!) resistor r=0.02609 c=0
rf17 (\2\:vdd! \3\:vdd!) resistor r=0.1063 c=0
rf18 (\3\:vdd! \4\:vdd!) resistor r=0.1044 c=0
rf19 (\4\:vdd! vdd!) resistor r=0.06674 c=0
rf20 (vdd! \5\:vdd!) resistor r=0.1518 c=0
rf21 (\5\:vdd! vdd!) resistor r=0.1358 c=0
rf22 (vdd! \6\:vdd!) resistor r=0.0436 c=0
rf23 (\6\:vdd! \7\:vdd!) resistor r=0.4398 c=0
rf24 (\3\:vdd! \8\:vdd!) resistor r=0.4 c=0
rf25 (\5\:vdd! \9\:vdd!) resistor r=0.4844 c=0
rf27 (B \1\:B) resistor r=0.04913 c=0
rf29 (\1\:gnd! \2\:gnd!) resistor r=0.4481 c=0
rf30 (\2\:gnd! \3\:gnd!) resistor r=0.1073 c=0
rf31 (\3\:gnd! \4\:gnd!) resistor r=0.1061 c=0
rf32 (\4\:gnd! 0) resistor r=0.06321 c=0
rf33 (0 \5\:gnd!) resistor r=0.159 c=0
rf34 (\5\:gnd! \6\:gnd!) resistor r=0.1812 c=0
rf35 (\3\:gnd! \7\:gnd!) resistor r=0.385 c=0
rf36 (\5\:gnd! \8\:gnd!) resistor r=0.4644 c=0
rf37 (\6\:gnd! \9\:gnd!) resistor r=0.4233 c=0
rg1 (\3\:A \4\:A) resistor r=152.382 c=0
rg2 (\4\:A \2\:A) resistor r=10.7763 c=0
rg3 (\4\:A \5\:A) resistor r=56.5484 c=0
rg4 (\6\:Ai \5\:Ai) resistor r=438.925 c=0
rg5 (\5\:Ai \7\:Ai) resistor r=89.7447 c=0
rg6 (\8\:A \9\:A) resistor r=257.237 c=0
rg7 (\9\:A \6\:A) resistor r=27.4119 c=0
rg8 (\9\:A \10\:A) resistor r=53.5985 c=0
rg9 (Bi \2\:Bi) resistor r=2.0523 c=0
rg10 (\2\:Bi \3\:Bi) resistor r=38.5093 c=0
rg11 (\2\:Bi \4\:Bi) resistor r=170.801 c=0
rg12 (\1\:B \2\:B) resistor r=7.3761 c=0
rg13 (\2\:B \3\:B) resistor r=170.445 c=0
rg14 (\3\:B \4\:B) resistor r=337.766 c=0
rg15 (\4\:B \5\:B) resistor r=299.266 c=0
rg16 (\2\:B \6\:B) resistor r=38.7782 c=0
MP5 (\1\:vdd! \3\:B \7\:Bi vdd!) pmos1 w=1e-06 l=1.8e-07 as=1.2e-12 \
        ad=1.2e-12 ps=5.2u pd=5.2u m=(1)*(1)
MP4 (Ai \3\:A \7\:vdd! vdd!) pmos1 w=1e-06 l=1.8e-07 as=1.2e-12 ad=1.2e-12 \
        ps=5.2u pd=5.2u m=(1)*(1)
MP0 (net8 \7\:Ai \9\:vdd! vdd!) pmos1 w=1e-06 l=1.8e-07 as=1.2e-12 \
        ad=1.2e-12 ps=5.2u pd=5.2u m=(1)*(1)
MP1 (\6\:Out \4\:B net8 vdd!) pmos1 w=1e-06 l=1.8e-07 as=1.2e-12 \
        ad=1.2e-12 ps=5.2u pd=5.2u m=(1)*(1)
MP3 (net022 \8\:A \4\:Out vdd!) pmos1 w=1e-06 l=1.8e-07 as=1.2e-12 \
        ad=1.2e-12 ps=5.2u pd=5.2u m=(1)*(1)
MP2 (\8\:vdd! \4\:Bi net022 vdd!) pmos1 w=1e-06 l=1.8e-07 as=1.2e-12 \
        ad=1.2e-12 ps=5.2u pd=5.2u m=(1)*(1)
MN5 (\1\:gnd! \6\:B \5\:Bi 0) nmos1 w=8e-07 l=1.8e-07 as=1.2e-12 \
        ad=1.2e-12 ps=5.2u pd=5.2u m=(1)*(1)
MN4 (\3\:Ai \5\:A \9\:gnd! 0) nmos1 w=8e-07 l=1.8e-07 as=1.2e-12 \
        ad=1.2e-12 ps=5.2u pd=5.2u m=(1)*(1)
MN3 (net17 \5\:B \8\:gnd! 0) nmos1 w=8e-07 l=1.8e-07 as=1.2e-12 ad=1.2e-12 \
        ps=5.2u pd=5.2u m=(1)*(1)
MN2 (\5\:Out \10\:A net17 0) nmos1 w=8e-07 l=1.8e-07 as=1.2e-12 ad=1.2e-12 \
        ps=5.2u pd=5.2u m=(1)*(1)
MN0 (net32 \6\:Ai \1\:Out 0) nmos1 w=8e-07 l=1.8e-07 as=1.2e-12 ad=1.2e-12 \
        ps=5.2u pd=5.2u m=(1)*(1)
MN1 (\7\:gnd! \3\:Bi net32 0) nmos1 w=8e-07 l=1.8e-07 as=1.2e-12 \
        ad=1.2e-12 ps=5.2u pd=5.2u m=(1)*(1)
simulatorOptions options reltol=1e-3 vabstol=1e-6 iabstol=1e-12 temp=27 \
    tnom=27 scalem=1.0 scale=1.0 gmin=1e-12 rforce=1 maxnotes=5 maxwarns=5 \
    digits=5 cols=80 pivrel=1e-3 sensfile="../psf/sens.output" \
    checklimitdest=psf
tran tran stop=30n write="spectre.ic" writefinal="spectre.fc" \
    annotate=status maxiters=5
finalTimeOP info what=oppoint where=rawfile
modelParameter info what=models where=rawfile
element info what=inst where=rawfile
outputParameter info what=output where=rawfile
designParamVals info what=parameters where=rawfile
primitives info what=primitives where=rawfile
subckts info what=subckts  where=rawfile
saveOptions options save=allpub
