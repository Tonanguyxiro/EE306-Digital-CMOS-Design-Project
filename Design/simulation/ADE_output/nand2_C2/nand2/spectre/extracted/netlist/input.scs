// Generated for: spectre
// Generated on: May 21 19:38:40 2021
// Design library name: multiplier
// Design cell name: nand2
// Design view name: extracted
simulator lang=spectre
global 0
include "/home/SME_VLSI/VLSI_57/306cadence/test_files/2_NAND_C2.input"
include "/home/SME_VLSI/306cadence/assuraTech/oa_2014/gpdk/../models/gpdk.scs" section=NN

// Library name: multiplier
// Cell name: nand2
// View name: extracted
\+8 (Out gnd!) capacitor c=6.31275e-16
\+7 (B gnd!) capacitor c=1.09572e-15
\+6 (B Out) capacitor c=3.33082e-15
\+5 (A gnd!) capacitor c=5.82727e-16
\+4 (A Out) capacitor c=3.77172e-15
\+3 (A B) capacitor c=3.5106e-16
\+2 (vdd! Out) capacitor c=2.81485e-15
\+1 (vdd! B) capacitor c=6.61574e-16
\+0 (vdd! A) capacitor c=6.95233e-16
\+12 (vdd! B Out vdd!) pmos1 w=4e-06 l=1.8e-07 as=1.26e-12 ad=2.16e-12 \
        ps=6.3e-07 pd=5.08e-06 m=(1)*(1)
\+11 (Out A vdd! vdd!) pmos1 w=4e-06 l=1.8e-07 as=2.16e-12 ad=1.26e-12 \
        ps=5.08e-06 pd=6.3e-07 m=(1)*(1)
\+10 (gnd! B 6 gnd!) nmos1 w=3.2e-06 l=1.8e-07 as=1.008e-12 ad=1.728e-12 \
        ps=6.3e-07 pd=4.28e-06 m=(1)*(1)
\+9 (6 A Out gnd!) nmos1 w=3.2e-06 l=1.8e-07 as=1.728e-12 ad=1.008e-12 \
        ps=4.28e-06 pd=6.3e-07 m=(1)*(1)
simulatorOptions options reltol=1e-3 vabstol=1e-6 iabstol=1e-12 temp=27 \
    tnom=27 scalem=1.0 scale=1.0 gmin=1e-12 rforce=1 maxnotes=5 maxwarns=5 \
    digits=5 cols=80 pivrel=1e-3 sensfile="../psf/sens.output" \
    checklimitdest=psf
tran tran stop=10n write="spectre.ic" writefinal="spectre.fc" \
    annotate=status maxiters=5
finalTimeOP info what=oppoint where=rawfile
modelParameter info what=models where=rawfile
element info what=inst where=rawfile
outputParameter info what=output where=rawfile
designParamVals info what=parameters where=rawfile
primitives info what=primitives where=rawfile
subckts info what=subckts  where=rawfile
saveOptions options save=allpub
