// Generated for: spectre
// Generated on: May 23 20:18:01 2021
// Design library name: multiplier
// Design cell name: 4X4_multiplier
// Design view name: extracted
simulator lang=spectre
global 0
include "/home/SME_VLSI/VLSI_57/306cadence/test_files/4x4_mul_11100001.input"
include "/home/SME_VLSI/306cadence/assuraTech/oa_2014/gpdk/../models/gpdk.scs" section=NN

// Library name: multiplier
// Cell name: 4X4_multiplier
// View name: extracted
\+455 (vdd! X0 212 vdd!) pmos1 w=4e-06 l=1.8e-07 as=1.26e-12 ad=2.16e-12 \
        ps=6.3e-07 pd=5.08e-06 m=(1)*(1)
\+454 (vdd! X0 211 vdd!) pmos1 w=4e-06 l=1.8e-07 as=1.26e-12 ad=2.16e-12 \
        ps=6.3e-07 pd=5.08e-06 m=(1)*(1)
\+453 (185 206 vdd! vdd!) pmos1 w=4e-06 l=1.8e-07 as=2.16e-12 ad=2.16e-12 \
        ps=5.08e-06 pd=5.08e-06 m=(1)*(1)
\+452 (198 205 vdd! vdd!) pmos1 w=4e-06 l=1.8e-07 as=2.16e-12 ad=2.16e-12 \
        ps=5.08e-06 pd=5.08e-06 m=(1)*(1)
\+451 (vdd! 204 214 vdd!) pmos1 w=4e-06 l=1.8e-07 as=2.16e-12 ad=2.16e-12 \
        ps=5.08e-06 pd=5.08e-06 m=(1)*(1)
\+450 (vdd! 203 213 vdd!) pmos1 w=4e-06 l=1.8e-07 as=2.16e-12 ad=2.16e-12 \
        ps=5.08e-06 pd=5.08e-06 m=(1)*(1)
\+449 (211 Y2 vdd! vdd!) pmos1 w=4e-06 l=1.8e-07 as=2.16e-12 ad=1.26e-12 \
        ps=5.08e-06 pd=6.3e-07 m=(1)*(1)
\+448 (212 Y3 vdd! vdd!) pmos1 w=4e-06 l=1.8e-07 as=2.16e-12 ad=1.26e-12 \
        ps=5.08e-06 pd=6.3e-07 m=(1)*(1)
\+447 (vdd! Y1 206 vdd!) pmos1 w=4e-06 l=1.8e-07 as=1.26e-12 ad=2.16e-12 \
        ps=6.3e-07 pd=5.08e-06 m=(1)*(1)
\+446 (vdd! X1 205 vdd!) pmos1 w=4e-06 l=1.8e-07 as=1.26e-12 ad=2.16e-12 \
        ps=6.3e-07 pd=5.08e-06 m=(1)*(1)
\+445 (vdd! 214 209 vdd!) pmos1 w=4e-06 l=1.8e-07 as=1.26e-12 ad=2.16e-12 \
        ps=6.3e-07 pd=5.08e-06 m=(1)*(1)
\+444 (vdd! 213 207 vdd!) pmos1 w=4e-06 l=1.8e-07 as=1.26e-12 ad=2.16e-12 \
        ps=6.3e-07 pd=5.08e-06 m=(1)*(1)
\+443 (vdd! 212 203 vdd!) pmos1 w=4e-06 l=1.8e-07 as=2.16e-12 ad=2.16e-12 \
        ps=5.08e-06 pd=5.08e-06 m=(1)*(1)
\+442 (vdd! 211 204 vdd!) pmos1 w=4e-06 l=1.8e-07 as=2.16e-12 ad=2.16e-12 \
        ps=5.08e-06 pd=5.08e-06 m=(1)*(1)
\+441 (206 X0 vdd! vdd!) pmos1 w=4e-06 l=1.8e-07 as=2.16e-12 ad=1.26e-12 \
        ps=5.08e-06 pd=6.3e-07 m=(1)*(1)
\+440 (205 Y0 vdd! vdd!) pmos1 w=4e-06 l=1.8e-07 as=2.16e-12 ad=1.26e-12 \
        ps=5.08e-06 pd=6.3e-07 m=(1)*(1)
\+439 (209 132 Z2 vdd!) pmos1 w=4e-06 l=1.8e-07 as=2.16e-12 ad=1.26e-12 \
        ps=5.08e-06 pd=6.3e-07 m=(1)*(1)
\+438 (207 145 Z3 vdd!) pmos1 w=4e-06 l=1.8e-07 as=2.16e-12 ad=1.26e-12 \
        ps=5.08e-06 pd=6.3e-07 m=(1)*(1)
\+437 (Z2 204 202 vdd!) pmos1 w=4e-06 l=1.8e-07 as=1.26e-12 ad=2.18e-12 \
        ps=6.3e-07 pd=5.09e-06 m=(1)*(1)
\+436 (vdd! 204 192 vdd!) pmos1 w=4e-06 l=1.8e-07 as=1.26e-12 ad=2.16e-12 \
        ps=6.3e-07 pd=5.08e-06 m=(1)*(1)
\+435 (Z3 203 200 vdd!) pmos1 w=4e-06 l=1.8e-07 as=1.26e-12 ad=2.18e-12 \
        ps=6.3e-07 pd=5.09e-06 m=(1)*(1)
\+434 (vdd! 203 191 vdd!) pmos1 w=4e-06 l=1.8e-07 as=1.26e-12 ad=2.16e-12 \
        ps=6.3e-07 pd=5.08e-06 m=(1)*(1)
\+433 (vdd! 198 197 vdd!) pmos1 w=4e-06 l=1.8e-07 as=2.16e-12 ad=2.16e-12 \
        ps=5.08e-06 pd=5.08e-06 m=(1)*(1)
\+432 (135 190 vdd! vdd!) pmos1 w=4e-06 l=1.8e-07 as=2.16e-12 ad=2.16e-12 \
        ps=5.08e-06 pd=5.08e-06 m=(1)*(1)
\+431 (202 196 vdd! vdd!) pmos1 w=4e-06 l=1.8e-07 as=2.14e-12 ad=1.26e-12 \
        ps=5.07e-06 pd=6.3e-07 m=(1)*(1)
\+430 (192 132 vdd! vdd!) pmos1 w=4e-06 l=1.8e-07 as=2.16e-12 ad=1.26e-12 \
        ps=5.08e-06 pd=6.3e-07 m=(1)*(1)
\+429 (200 195 vdd! vdd!) pmos1 w=4e-06 l=1.8e-07 as=2.14e-12 ad=1.26e-12 \
        ps=5.07e-06 pd=6.3e-07 m=(1)*(1)
\+428 (191 145 vdd! vdd!) pmos1 w=4e-06 l=1.8e-07 as=2.16e-12 ad=1.26e-12 \
        ps=5.08e-06 pd=6.3e-07 m=(1)*(1)
\+427 (vdd! 198 190 vdd!) pmos1 w=4e-06 l=1.8e-07 as=1.26e-12 ad=2.16e-12 \
        ps=6.3e-07 pd=5.08e-06 m=(1)*(1)
\+426 (vdd! 197 193 vdd!) pmos1 w=4e-06 l=1.8e-07 as=1.26e-12 ad=2.14e-12 \
        ps=6.3e-07 pd=5.07e-06 m=(1)*(1)
\+425 (vdd! 192 147 vdd!) pmos1 w=4e-06 l=1.8e-07 as=2.16e-12 ad=2.16e-12 \
        ps=5.08e-06 pd=5.08e-06 m=(1)*(1)
\+424 (196 132 vdd! vdd!) pmos1 w=4e-06 l=1.8e-07 as=2.16e-12 ad=2.16e-12 \
        ps=5.08e-06 pd=5.08e-06 m=(1)*(1)
\+423 (vdd! 191 148 vdd!) pmos1 w=4e-06 l=1.8e-07 as=2.16e-12 ad=2.16e-12 \
        ps=5.08e-06 pd=5.08e-06 m=(1)*(1)
\+422 (195 145 vdd! vdd!) pmos1 w=4e-06 l=1.8e-07 as=2.16e-12 ad=2.16e-12 \
        ps=5.08e-06 pd=5.08e-06 m=(1)*(1)
\+421 (193 185 Z1 vdd!) pmos1 w=4e-06 l=1.8e-07 as=2.18e-12 ad=1.26e-12 \
        ps=5.09e-06 pd=6.3e-07 m=(1)*(1)
\+420 (190 185 vdd! vdd!) pmos1 w=4e-06 l=1.8e-07 as=2.16e-12 ad=1.26e-12 \
        ps=5.08e-06 pd=6.3e-07 m=(1)*(1)
\+419 (162 186 vdd! vdd!) pmos1 w=4e-06 l=1.8e-07 as=2.16e-12 ad=2.16e-12 \
        ps=5.08e-06 pd=5.08e-06 m=(1)*(1)
\+418 (Z1 198 188 vdd!) pmos1 w=4e-06 l=1.8e-07 as=1.26e-12 ad=2.16e-12 \
        ps=6.3e-07 pd=5.08e-06 m=(1)*(1)
\+417 (188 187 vdd! vdd!) pmos1 w=4e-06 l=1.8e-07 as=2.16e-12 ad=1.26e-12 \
        ps=5.08e-06 pd=6.3e-07 m=(1)*(1)
\+416 (vdd! Y2 183 vdd!) pmos1 w=4e-06 l=1.8e-07 as=1.26e-12 ad=2.16e-12 \
        ps=6.3e-07 pd=5.08e-06 m=(1)*(1)
\+415 (vdd! Y3 184 vdd!) pmos1 w=4e-06 l=1.8e-07 as=1.26e-12 ad=2.16e-12 \
        ps=6.3e-07 pd=5.08e-06 m=(1)*(1)
\+414 (vdd! Y1 186 vdd!) pmos1 w=4e-06 l=1.8e-07 as=1.26e-12 ad=2.16e-12 \
        ps=6.3e-07 pd=5.08e-06 m=(1)*(1)
\+413 (184 X1 vdd! vdd!) pmos1 w=4e-06 l=1.8e-07 as=2.16e-12 ad=1.26e-12 \
        ps=5.08e-06 pd=6.3e-07 m=(1)*(1)
\+412 (183 X1 vdd! vdd!) pmos1 w=4e-06 l=1.8e-07 as=2.16e-12 ad=1.26e-12 \
        ps=5.08e-06 pd=6.3e-07 m=(1)*(1)
\+411 (186 X1 vdd! vdd!) pmos1 w=4e-06 l=1.8e-07 as=2.16e-12 ad=1.26e-12 \
        ps=5.08e-06 pd=6.3e-07 m=(1)*(1)
\+410 (187 185 vdd! vdd!) pmos1 w=4e-06 l=1.8e-07 as=2.16e-12 ad=2.16e-12 \
        ps=5.08e-06 pd=5.08e-06 m=(1)*(1)
\+409 (vdd! 172 181 vdd!) pmos1 w=4e-06 l=1.8e-07 as=1.26e-12 ad=2.16e-12 \
        ps=6.3e-07 pd=5.08e-06 m=(1)*(1)
\+408 (vdd! 171 179 vdd!) pmos1 w=4e-06 l=1.8e-07 as=1.26e-12 ad=2.16e-12 \
        ps=6.3e-07 pd=5.08e-06 m=(1)*(1)
\+407 (181 165 153 vdd!) pmos1 w=4e-06 l=1.8e-07 as=2.16e-12 ad=1.26e-12 \
        ps=5.08e-06 pd=6.3e-07 m=(1)*(1)
\+406 (179 164 152 vdd!) pmos1 w=4e-06 l=1.8e-07 as=2.16e-12 ad=1.26e-12 \
        ps=5.08e-06 pd=6.3e-07 m=(1)*(1)
\+405 (vdd! 183 164 vdd!) pmos1 w=4e-06 l=1.8e-07 as=2.16e-12 ad=2.16e-12 \
        ps=5.08e-06 pd=5.08e-06 m=(1)*(1)
\+404 (vdd! 184 165 vdd!) pmos1 w=4e-06 l=1.8e-07 as=2.16e-12 ad=2.16e-12 \
        ps=5.08e-06 pd=5.08e-06 m=(1)*(1)
\+403 (156 170 vdd! vdd!) pmos1 w=4e-06 l=1.8e-07 as=2.16e-12 ad=2.16e-12 \
        ps=5.08e-06 pd=5.08e-06 m=(1)*(1)
\+402 (vdd! 163 177 vdd!) pmos1 w=4e-06 l=1.8e-07 as=1.26e-12 ad=2.16e-12 \
        ps=6.3e-07 pd=5.08e-06 m=(1)*(1)
\+401 (153 118 175 vdd!) pmos1 w=4e-06 l=1.8e-07 as=1.26e-12 ad=2.16e-12 \
        ps=6.3e-07 pd=5.08e-06 m=(1)*(1)
\+400 (152 109 173 vdd!) pmos1 w=4e-06 l=1.8e-07 as=1.26e-12 ad=2.16e-12 \
        ps=6.3e-07 pd=5.08e-06 m=(1)*(1)
\+399 (vdd! X2 170 vdd!) pmos1 w=4e-06 l=1.8e-07 as=1.26e-12 ad=2.16e-12 \
        ps=6.3e-07 pd=5.08e-06 m=(1)*(1)
\+398 (177 156 141 vdd!) pmos1 w=4e-06 l=1.8e-07 as=2.16e-12 ad=1.26e-12 \
        ps=5.08e-06 pd=6.3e-07 m=(1)*(1)
\+397 (vdd! 118 172 vdd!) pmos1 w=4e-06 l=1.8e-07 as=2.16e-12 ad=2.16e-12 \
        ps=5.08e-06 pd=5.08e-06 m=(1)*(1)
\+396 (vdd! 109 171 vdd!) pmos1 w=4e-06 l=1.8e-07 as=2.16e-12 ad=2.16e-12 \
        ps=5.08e-06 pd=5.08e-06 m=(1)*(1)
\+395 (175 169 vdd! vdd!) pmos1 w=4e-06 l=1.8e-07 as=2.16e-12 ad=1.26e-12 \
        ps=5.08e-06 pd=6.3e-07 m=(1)*(1)
\+394 (173 168 vdd! vdd!) pmos1 w=4e-06 l=1.8e-07 as=2.16e-12 ad=1.26e-12 \
        ps=5.08e-06 pd=6.3e-07 m=(1)*(1)
\+393 (170 Y0 vdd! vdd!) pmos1 w=4e-06 l=1.8e-07 as=2.16e-12 ad=1.26e-12 \
        ps=5.08e-06 pd=6.3e-07 m=(1)*(1)
\+392 (vdd! 118 161 vdd!) pmos1 w=4e-06 l=1.8e-07 as=1.26e-12 ad=2.16e-12 \
        ps=6.3e-07 pd=5.08e-06 m=(1)*(1)
\+391 (vdd! 109 160 vdd!) pmos1 w=4e-06 l=1.8e-07 as=1.26e-12 ad=2.16e-12 \
        ps=6.3e-07 pd=5.08e-06 m=(1)*(1)
\+390 (141 162 166 vdd!) pmos1 w=4e-06 l=1.8e-07 as=1.26e-12 ad=2.16e-12 \
        ps=6.3e-07 pd=5.08e-06 m=(1)*(1)
\+389 (169 165 vdd! vdd!) pmos1 w=4e-06 l=1.8e-07 as=2.16e-12 ad=2.16e-12 \
        ps=5.08e-06 pd=5.08e-06 m=(1)*(1)
\+388 (168 164 vdd! vdd!) pmos1 w=4e-06 l=1.8e-07 as=2.16e-12 ad=2.16e-12 \
        ps=5.08e-06 pd=5.08e-06 m=(1)*(1)
\+387 (vdd! 162 163 vdd!) pmos1 w=4e-06 l=1.8e-07 as=2.16e-12 ad=2.16e-12 \
        ps=5.08e-06 pd=5.08e-06 m=(1)*(1)
\+386 (161 165 vdd! vdd!) pmos1 w=4e-06 l=1.8e-07 as=2.16e-12 ad=1.26e-12 \
        ps=5.08e-06 pd=6.3e-07 m=(1)*(1)
\+385 (160 164 vdd! vdd!) pmos1 w=4e-06 l=1.8e-07 as=2.16e-12 ad=1.26e-12 \
        ps=5.08e-06 pd=6.3e-07 m=(1)*(1)
\+384 (166 159 vdd! vdd!) pmos1 w=4e-06 l=1.8e-07 as=2.16e-12 ad=1.26e-12 \
        ps=5.08e-06 pd=6.3e-07 m=(1)*(1)
\+383 (vdd! 152 157 vdd!) pmos1 w=4e-06 l=1.8e-07 as=2.16e-12 ad=2.16e-12 \
        ps=5.08e-06 pd=5.08e-06 m=(1)*(1)
\+382 (vdd! 153 158 vdd!) pmos1 w=4e-06 l=1.8e-07 as=2.16e-12 ad=2.16e-12 \
        ps=5.08e-06 pd=5.08e-06 m=(1)*(1)
\+381 (vdd! 162 149 vdd!) pmos1 w=4e-06 l=1.8e-07 as=1.26e-12 ad=2.16e-12 \
        ps=6.3e-07 pd=5.08e-06 m=(1)*(1)
\+380 (vdd! 161 117 vdd!) pmos1 w=4e-06 l=1.8e-07 as=1.26e-12 ad=2.16e-12 \
        ps=6.3e-07 pd=5.08e-06 m=(1)*(1)
\+379 (vdd! 160 116 vdd!) pmos1 w=4e-06 l=1.8e-07 as=1.26e-12 ad=2.16e-12 \
        ps=6.3e-07 pd=5.08e-06 m=(1)*(1)
\+378 (159 156 vdd! vdd!) pmos1 w=4e-06 l=1.8e-07 as=2.16e-12 ad=2.16e-12 \
        ps=5.08e-06 pd=5.08e-06 m=(1)*(1)
\+377 (149 156 vdd! vdd!) pmos1 w=4e-06 l=1.8e-07 as=2.16e-12 ad=1.26e-12 \
        ps=5.08e-06 pd=6.3e-07 m=(1)*(1)
\+376 (117 144 vdd! vdd!) pmos1 w=4e-06 l=1.8e-07 as=2.16e-12 ad=1.26e-12 \
        ps=5.08e-06 pd=6.3e-07 m=(1)*(1)
\+375 (116 143 vdd! vdd!) pmos1 w=4e-06 l=1.8e-07 as=2.16e-12 ad=1.26e-12 \
        ps=5.08e-06 pd=6.3e-07 m=(1)*(1)
\+374 (vdd! 158 151 vdd!) pmos1 w=4e-06 l=1.8e-07 as=1.26e-12 ad=2.16e-12 \
        ps=6.3e-07 pd=5.08e-06 m=(1)*(1)
\+373 (vdd! 157 150 vdd!) pmos1 w=4e-06 l=1.8e-07 as=1.26e-12 ad=2.16e-12 \
        ps=6.3e-07 pd=5.08e-06 m=(1)*(1)
\+372 (vdd! 141 146 vdd!) pmos1 w=4e-06 l=1.8e-07 as=2.16e-12 ad=2.16e-12 \
        ps=5.08e-06 pd=5.08e-06 m=(1)*(1)
\+371 (151 148 Z4 vdd!) pmos1 w=4e-06 l=1.8e-07 as=2.16e-12 ad=1.26e-12 \
        ps=5.08e-06 pd=6.3e-07 m=(1)*(1)
\+370 (150 147 145 vdd!) pmos1 w=4e-06 l=1.8e-07 as=2.16e-12 ad=1.26e-12 \
        ps=5.08e-06 pd=6.3e-07 m=(1)*(1)
\+369 (vdd! 149 108 vdd!) pmos1 w=4e-06 l=1.8e-07 as=1.26e-12 ad=2.16e-12 \
        ps=6.3e-07 pd=5.08e-06 m=(1)*(1)
\+368 (vdd! 148 144 vdd!) pmos1 w=4e-06 l=1.8e-07 as=1.26e-12 ad=2.16e-12 \
        ps=6.3e-07 pd=5.08e-06 m=(1)*(1)
\+367 (vdd! 147 143 vdd!) pmos1 w=4e-06 l=1.8e-07 as=1.26e-12 ad=2.16e-12 \
        ps=6.3e-07 pd=5.08e-06 m=(1)*(1)
\+366 (108 131 vdd! vdd!) pmos1 w=4e-06 l=1.8e-07 as=2.16e-12 ad=1.26e-12 \
        ps=5.08e-06 pd=6.3e-07 m=(1)*(1)
\+365 (144 153 vdd! vdd!) pmos1 w=4e-06 l=1.8e-07 as=2.16e-12 ad=1.26e-12 \
        ps=5.08e-06 pd=6.3e-07 m=(1)*(1)
\+364 (143 152 vdd! vdd!) pmos1 w=4e-06 l=1.8e-07 as=2.16e-12 ad=1.26e-12 \
        ps=5.08e-06 pd=6.3e-07 m=(1)*(1)
\+363 (vdd! 146 140 vdd!) pmos1 w=4e-06 l=1.8e-07 as=1.26e-12 ad=2.16e-12 \
        ps=6.3e-07 pd=5.08e-06 m=(1)*(1)
\+362 (Z4 153 138 vdd!) pmos1 w=4e-06 l=1.8e-07 as=1.26e-12 ad=2.16e-12 \
        ps=6.3e-07 pd=5.08e-06 m=(1)*(1)
\+361 (145 152 136 vdd!) pmos1 w=4e-06 l=1.8e-07 as=1.26e-12 ad=2.16e-12 \
        ps=6.3e-07 pd=5.08e-06 m=(1)*(1)
\+360 (140 135 132 vdd!) pmos1 w=4e-06 l=1.8e-07 as=2.16e-12 ad=1.26e-12 \
        ps=5.08e-06 pd=6.3e-07 m=(1)*(1)
\+359 (vdd! 135 131 vdd!) pmos1 w=4e-06 l=1.8e-07 as=1.26e-12 ad=2.16e-12 \
        ps=6.3e-07 pd=5.08e-06 m=(1)*(1)
\+358 (138 134 vdd! vdd!) pmos1 w=4e-06 l=1.8e-07 as=2.16e-12 ad=1.26e-12 \
        ps=5.08e-06 pd=6.3e-07 m=(1)*(1)
\+357 (136 133 vdd! vdd!) pmos1 w=4e-06 l=1.8e-07 as=2.16e-12 ad=1.26e-12 \
        ps=5.08e-06 pd=6.3e-07 m=(1)*(1)
\+356 (vdd! 148 134 vdd!) pmos1 w=4e-06 l=1.8e-07 as=2.16e-12 ad=2.16e-12 \
        ps=5.08e-06 pd=5.08e-06 m=(1)*(1)
\+355 (vdd! 147 133 vdd!) pmos1 w=4e-06 l=1.8e-07 as=2.16e-12 ad=2.16e-12 \
        ps=5.08e-06 pd=5.08e-06 m=(1)*(1)
\+354 (131 141 vdd! vdd!) pmos1 w=4e-06 l=1.8e-07 as=2.16e-12 ad=1.26e-12 \
        ps=5.08e-06 pd=6.3e-07 m=(1)*(1)
\+353 (132 141 129 vdd!) pmos1 w=4e-06 l=1.8e-07 as=1.26e-12 ad=2.16e-12 \
        ps=6.3e-07 pd=5.08e-06 m=(1)*(1)
\+352 (129 126 vdd! vdd!) pmos1 w=4e-06 l=1.8e-07 as=2.16e-12 ad=1.26e-12 \
        ps=5.08e-06 pd=6.3e-07 m=(1)*(1)
\+351 (vdd! 135 126 vdd!) pmos1 w=4e-06 l=1.8e-07 as=2.16e-12 ad=2.16e-12 \
        ps=5.08e-06 pd=5.08e-06 m=(1)*(1)
\+350 (127 116 vdd! vdd!) pmos1 w=4e-06 l=1.8e-07 as=2.16e-12 ad=2.16e-12 \
        ps=5.08e-06 pd=5.08e-06 m=(1)*(1)
\+349 (128 117 vdd! vdd!) pmos1 w=4e-06 l=1.8e-07 as=2.16e-12 ad=2.16e-12 \
        ps=5.08e-06 pd=5.08e-06 m=(1)*(1)
\+348 (vdd! 128 123 vdd!) pmos1 w=4e-06 l=1.8e-07 as=1.26e-12 ad=2.16e-12 \
        ps=6.3e-07 pd=5.08e-06 m=(1)*(1)
\+347 (vdd! 127 122 vdd!) pmos1 w=4e-06 l=1.8e-07 as=1.26e-12 ad=2.16e-12 \
        ps=6.3e-07 pd=5.08e-06 m=(1)*(1)
\+346 (123 84 Z5 vdd!) pmos1 w=4e-06 l=1.8e-07 as=2.16e-12 ad=1.26e-12 \
        ps=5.08e-06 pd=6.3e-07 m=(1)*(1)
\+345 (122 83 118 vdd!) pmos1 w=4e-06 l=1.8e-07 as=2.16e-12 ad=1.26e-12 \
        ps=5.08e-06 pd=6.3e-07 m=(1)*(1)
\+344 (vdd! 84 111 vdd!) pmos1 w=4e-06 l=1.8e-07 as=1.26e-12 ad=2.16e-12 \
        ps=6.3e-07 pd=5.08e-06 m=(1)*(1)
\+343 (vdd! 83 110 vdd!) pmos1 w=4e-06 l=1.8e-07 as=1.26e-12 ad=2.16e-12 \
        ps=6.3e-07 pd=5.08e-06 m=(1)*(1)
\+342 (121 108 vdd! vdd!) pmos1 w=4e-06 l=1.8e-07 as=2.16e-12 ad=2.16e-12 \
        ps=5.08e-06 pd=5.08e-06 m=(1)*(1)
\+341 (vdd! 121 119 vdd!) pmos1 w=4e-06 l=1.8e-07 as=1.26e-12 ad=2.16e-12 \
        ps=6.3e-07 pd=5.08e-06 m=(1)*(1)
\+340 (111 117 vdd! vdd!) pmos1 w=4e-06 l=1.8e-07 as=2.16e-12 ad=1.26e-12 \
        ps=5.08e-06 pd=6.3e-07 m=(1)*(1)
\+339 (110 116 vdd! vdd!) pmos1 w=4e-06 l=1.8e-07 as=2.16e-12 ad=1.26e-12 \
        ps=5.08e-06 pd=6.3e-07 m=(1)*(1)
\+338 (119 77 109 vdd!) pmos1 w=4e-06 l=1.8e-07 as=2.16e-12 ad=1.26e-12 \
        ps=5.08e-06 pd=6.3e-07 m=(1)*(1)
\+337 (Z5 117 115 vdd!) pmos1 w=4e-06 l=1.8e-07 as=1.26e-12 ad=2.16e-12 \
        ps=6.3e-07 pd=5.08e-06 m=(1)*(1)
\+336 (118 116 114 vdd!) pmos1 w=4e-06 l=1.8e-07 as=1.26e-12 ad=2.16e-12 \
        ps=6.3e-07 pd=5.08e-06 m=(1)*(1)
\+335 (vdd! 77 103 vdd!) pmos1 w=4e-06 l=1.8e-07 as=1.26e-12 ad=2.16e-12 \
        ps=6.3e-07 pd=5.08e-06 m=(1)*(1)
\+334 (115 105 vdd! vdd!) pmos1 w=4e-06 l=1.8e-07 as=2.16e-12 ad=1.26e-12 \
        ps=5.08e-06 pd=6.3e-07 m=(1)*(1)
\+333 (114 104 vdd! vdd!) pmos1 w=4e-06 l=1.8e-07 as=2.16e-12 ad=1.26e-12 \
        ps=5.08e-06 pd=6.3e-07 m=(1)*(1)
\+332 (vdd! 111 60 vdd!) pmos1 w=4e-06 l=1.8e-07 as=1.26e-12 ad=2.16e-12 \
        ps=6.3e-07 pd=5.08e-06 m=(1)*(1)
\+331 (vdd! 110 59 vdd!) pmos1 w=4e-06 l=1.8e-07 as=1.26e-12 ad=2.16e-12 \
        ps=6.3e-07 pd=5.08e-06 m=(1)*(1)
\+330 (103 108 vdd! vdd!) pmos1 w=4e-06 l=1.8e-07 as=2.16e-12 ad=1.26e-12 \
        ps=5.08e-06 pd=6.3e-07 m=(1)*(1)
\+329 (109 108 107 vdd!) pmos1 w=4e-06 l=1.8e-07 as=1.26e-12 ad=2.16e-12 \
        ps=6.3e-07 pd=5.08e-06 m=(1)*(1)
\+328 (59 100 vdd! vdd!) pmos1 w=4e-06 l=1.8e-07 as=2.16e-12 ad=1.26e-12 \
        ps=5.08e-06 pd=6.3e-07 m=(1)*(1)
\+327 (60 101 vdd! vdd!) pmos1 w=4e-06 l=1.8e-07 as=2.16e-12 ad=1.26e-12 \
        ps=5.08e-06 pd=6.3e-07 m=(1)*(1)
\+326 (107 102 vdd! vdd!) pmos1 w=4e-06 l=1.8e-07 as=2.16e-12 ad=1.26e-12 \
        ps=5.08e-06 pd=6.3e-07 m=(1)*(1)
\+325 (105 84 vdd! vdd!) pmos1 w=4e-06 l=1.8e-07 as=2.16e-12 ad=2.16e-12 \
        ps=5.08e-06 pd=5.08e-06 m=(1)*(1)
\+324 (104 83 vdd! vdd!) pmos1 w=4e-06 l=1.8e-07 as=2.16e-12 ad=2.16e-12 \
        ps=5.08e-06 pd=5.08e-06 m=(1)*(1)
\+323 (vdd! 103 50 vdd!) pmos1 w=4e-06 l=1.8e-07 as=1.26e-12 ad=2.16e-12 \
        ps=6.3e-07 pd=5.08e-06 m=(1)*(1)
\+322 (vdd! 63 101 vdd!) pmos1 w=4e-06 l=1.8e-07 as=1.26e-12 ad=2.16e-12 \
        ps=6.3e-07 pd=5.08e-06 m=(1)*(1)
\+321 (vdd! 51 100 vdd!) pmos1 w=4e-06 l=1.8e-07 as=1.26e-12 ad=2.16e-12 \
        ps=6.3e-07 pd=5.08e-06 m=(1)*(1)
\+320 (50 91 vdd! vdd!) pmos1 w=4e-06 l=1.8e-07 as=2.16e-12 ad=1.26e-12 \
        ps=5.08e-06 pd=6.3e-07 m=(1)*(1)
\+319 (vdd! 63 99 vdd!) pmos1 w=4e-06 l=1.8e-07 as=2.16e-12 ad=2.16e-12 \
        ps=5.08e-06 pd=5.08e-06 m=(1)*(1)
\+318 (vdd! 51 98 vdd!) pmos1 w=4e-06 l=1.8e-07 as=2.16e-12 ad=2.16e-12 \
        ps=5.08e-06 pd=5.08e-06 m=(1)*(1)
\+317 (102 77 vdd! vdd!) pmos1 w=4e-06 l=1.8e-07 as=2.16e-12 ad=2.16e-12 \
        ps=5.08e-06 pd=5.08e-06 m=(1)*(1)
\+316 (101 86 vdd! vdd!) pmos1 w=4e-06 l=1.8e-07 as=2.16e-12 ad=1.26e-12 \
        ps=5.08e-06 pd=6.3e-07 m=(1)*(1)
\+315 (100 85 vdd! vdd!) pmos1 w=4e-06 l=1.8e-07 as=2.16e-12 ad=1.26e-12 \
        ps=5.08e-06 pd=6.3e-07 m=(1)*(1)
\+314 (vdd! 82 91 vdd!) pmos1 w=4e-06 l=1.8e-07 as=1.26e-12 ad=2.16e-12 \
        ps=6.3e-07 pd=5.08e-06 m=(1)*(1)
\+313 (vdd! 99 93 vdd!) pmos1 w=4e-06 l=1.8e-07 as=1.26e-12 ad=2.16e-12 \
        ps=6.3e-07 pd=5.08e-06 m=(1)*(1)
\+312 (vdd! 98 92 vdd!) pmos1 w=4e-06 l=1.8e-07 as=1.26e-12 ad=2.16e-12 \
        ps=6.3e-07 pd=5.08e-06 m=(1)*(1)
\+311 (vdd! 82 90 vdd!) pmos1 w=4e-06 l=1.8e-07 as=2.16e-12 ad=2.16e-12 \
        ps=5.08e-06 pd=5.08e-06 m=(1)*(1)
\+310 (97 86 vdd! vdd!) pmos1 w=4e-06 l=1.8e-07 as=2.16e-12 ad=2.16e-12 \
        ps=5.08e-06 pd=5.08e-06 m=(1)*(1)
\+309 (96 85 vdd! vdd!) pmos1 w=4e-06 l=1.8e-07 as=2.16e-12 ad=2.16e-12 \
        ps=5.08e-06 pd=5.08e-06 m=(1)*(1)
\+308 (91 71 vdd! vdd!) pmos1 w=4e-06 l=1.8e-07 as=2.16e-12 ad=1.26e-12 \
        ps=5.08e-06 pd=6.3e-07 m=(1)*(1)
\+307 (93 86 84 vdd!) pmos1 w=4e-06 l=1.8e-07 as=2.16e-12 ad=1.26e-12 \
        ps=5.08e-06 pd=6.3e-07 m=(1)*(1)
\+306 (92 85 83 vdd!) pmos1 w=4e-06 l=1.8e-07 as=2.16e-12 ad=1.26e-12 \
        ps=5.08e-06 pd=6.3e-07 m=(1)*(1)
\+305 (vdd! 90 87 vdd!) pmos1 w=4e-06 l=1.8e-07 as=1.26e-12 ad=2.16e-12 \
        ps=6.3e-07 pd=5.08e-06 m=(1)*(1)
\+304 (89 71 vdd! vdd!) pmos1 w=4e-06 l=1.8e-07 as=2.16e-12 ad=2.16e-12 \
        ps=5.08e-06 pd=5.08e-06 m=(1)*(1)
\+303 (87 71 77 vdd!) pmos1 w=4e-06 l=1.8e-07 as=2.16e-12 ad=1.26e-12 \
        ps=5.08e-06 pd=6.3e-07 m=(1)*(1)
\+302 (86 74 vdd! vdd!) pmos1 w=4e-06 l=1.8e-07 as=2.16e-12 ad=2.16e-12 \
        ps=5.08e-06 pd=5.08e-06 m=(1)*(1)
\+301 (85 73 vdd! vdd!) pmos1 w=4e-06 l=1.8e-07 as=2.16e-12 ad=2.16e-12 \
        ps=5.08e-06 pd=5.08e-06 m=(1)*(1)
\+300 (84 63 79 vdd!) pmos1 w=4e-06 l=1.8e-07 as=1.26e-12 ad=2.16e-12 \
        ps=6.3e-07 pd=5.08e-06 m=(1)*(1)
\+299 (83 51 78 vdd!) pmos1 w=4e-06 l=1.8e-07 as=1.26e-12 ad=2.16e-12 \
        ps=6.3e-07 pd=5.08e-06 m=(1)*(1)
\+298 (82 72 vdd! vdd!) pmos1 w=4e-06 l=1.8e-07 as=2.16e-12 ad=2.16e-12 \
        ps=5.08e-06 pd=5.08e-06 m=(1)*(1)
\+297 (79 97 vdd! vdd!) pmos1 w=4e-06 l=1.8e-07 as=2.16e-12 ad=1.26e-12 \
        ps=5.08e-06 pd=6.3e-07 m=(1)*(1)
\+296 (78 96 vdd! vdd!) pmos1 w=4e-06 l=1.8e-07 as=2.16e-12 ad=1.26e-12 \
        ps=5.08e-06 pd=6.3e-07 m=(1)*(1)
\+295 (77 82 75 vdd!) pmos1 w=4e-06 l=1.8e-07 as=1.26e-12 ad=2.16e-12 \
        ps=6.3e-07 pd=5.08e-06 m=(1)*(1)
\+294 (vdd! X2 74 vdd!) pmos1 w=4e-06 l=1.8e-07 as=1.26e-12 ad=2.16e-12 \
        ps=6.3e-07 pd=5.08e-06 m=(1)*(1)
\+293 (vdd! X2 73 vdd!) pmos1 w=4e-06 l=1.8e-07 as=1.26e-12 ad=2.16e-12 \
        ps=6.3e-07 pd=5.08e-06 m=(1)*(1)
\+292 (75 89 vdd! vdd!) pmos1 w=4e-06 l=1.8e-07 as=2.16e-12 ad=1.26e-12 \
        ps=5.08e-06 pd=6.3e-07 m=(1)*(1)
\+291 (74 Y3 vdd! vdd!) pmos1 w=4e-06 l=1.8e-07 as=2.16e-12 ad=1.26e-12 \
        ps=5.08e-06 pd=6.3e-07 m=(1)*(1)
\+290 (73 Y2 vdd! vdd!) pmos1 w=4e-06 l=1.8e-07 as=2.16e-12 ad=1.26e-12 \
        ps=5.08e-06 pd=6.3e-07 m=(1)*(1)
\+289 (vdd! Y1 72 vdd!) pmos1 w=4e-06 l=1.8e-07 as=1.26e-12 ad=2.16e-12 \
        ps=6.3e-07 pd=5.08e-06 m=(1)*(1)
\+288 (72 X2 vdd! vdd!) pmos1 w=4e-06 l=1.8e-07 as=2.16e-12 ad=1.26e-12 \
        ps=5.08e-06 pd=6.3e-07 m=(1)*(1)
\+287 (71 56 vdd! vdd!) pmos1 w=4e-06 l=1.8e-07 as=2.16e-12 ad=2.16e-12 \
        ps=5.08e-06 pd=5.08e-06 m=(1)*(1)
\+286 (70 60 vdd! vdd!) pmos1 w=4e-06 l=1.8e-07 as=2.16e-12 ad=2.16e-12 \
        ps=5.08e-06 pd=5.08e-06 m=(1)*(1)
\+285 (69 59 vdd! vdd!) pmos1 w=4e-06 l=1.8e-07 as=2.16e-12 ad=2.16e-12 \
        ps=5.08e-06 pd=5.08e-06 m=(1)*(1)
\+284 (vdd! 69 65 vdd!) pmos1 w=4e-06 l=1.8e-07 as=1.26e-12 ad=2.16e-12 \
        ps=6.3e-07 pd=5.08e-06 m=(1)*(1)
\+283 (vdd! 70 66 vdd!) pmos1 w=4e-06 l=1.8e-07 as=1.26e-12 ad=2.16e-12 \
        ps=6.3e-07 pd=5.08e-06 m=(1)*(1)
\+282 (vdd! 50 64 vdd!) pmos1 w=4e-06 l=1.8e-07 as=2.16e-12 ad=2.16e-12 \
        ps=5.08e-06 pd=5.08e-06 m=(1)*(1)
\+281 (66 28 Z6 vdd!) pmos1 w=4e-06 l=1.8e-07 as=2.16e-12 ad=1.26e-12 \
        ps=5.08e-06 pd=6.3e-07 m=(1)*(1)
\+280 (65 27 63 vdd!) pmos1 w=4e-06 l=1.8e-07 as=2.16e-12 ad=1.26e-12 \
        ps=5.08e-06 pd=6.3e-07 m=(1)*(1)
\+279 (vdd! 28 53 vdd!) pmos1 w=4e-06 l=1.8e-07 as=1.26e-12 ad=2.16e-12 \
        ps=6.3e-07 pd=5.08e-06 m=(1)*(1)
\+278 (vdd! 27 52 vdd!) pmos1 w=4e-06 l=1.8e-07 as=1.26e-12 ad=2.16e-12 \
        ps=6.3e-07 pd=5.08e-06 m=(1)*(1)
\+277 (vdd! X3 56 vdd!) pmos1 w=4e-06 l=1.8e-07 as=1.26e-12 ad=2.16e-12 \
        ps=6.3e-07 pd=5.08e-06 m=(1)*(1)
\+276 (vdd! 64 61 vdd!) pmos1 w=4e-06 l=1.8e-07 as=1.26e-12 ad=2.16e-12 \
        ps=6.3e-07 pd=5.08e-06 m=(1)*(1)
\+275 (53 60 vdd! vdd!) pmos1 w=4e-06 l=1.8e-07 as=2.16e-12 ad=1.26e-12 \
        ps=5.08e-06 pd=6.3e-07 m=(1)*(1)
\+274 (52 59 vdd! vdd!) pmos1 w=4e-06 l=1.8e-07 as=2.16e-12 ad=1.26e-12 \
        ps=5.08e-06 pd=6.3e-07 m=(1)*(1)
\+273 (63 59 57 vdd!) pmos1 w=4e-06 l=1.8e-07 as=1.26e-12 ad=2.16e-12 \
        ps=6.3e-07 pd=5.08e-06 m=(1)*(1)
\+272 (Z6 60 58 vdd!) pmos1 w=4e-06 l=1.8e-07 as=1.26e-12 ad=2.16e-12 \
        ps=6.3e-07 pd=5.08e-06 m=(1)*(1)
\+271 (56 Y0 vdd! vdd!) pmos1 w=4e-06 l=1.8e-07 as=2.16e-12 ad=1.26e-12 \
        ps=5.08e-06 pd=6.3e-07 m=(1)*(1)
\+270 (61 37 51 vdd!) pmos1 w=4e-06 l=1.8e-07 as=2.16e-12 ad=1.26e-12 \
        ps=5.08e-06 pd=6.3e-07 m=(1)*(1)
\+269 (58 49 vdd! vdd!) pmos1 w=4e-06 l=1.8e-07 as=2.16e-12 ad=1.26e-12 \
        ps=5.08e-06 pd=6.3e-07 m=(1)*(1)
\+268 (57 48 vdd! vdd!) pmos1 w=4e-06 l=1.8e-07 as=2.16e-12 ad=1.26e-12 \
        ps=5.08e-06 pd=6.3e-07 m=(1)*(1)
\+267 (vdd! 53 Z7 vdd!) pmos1 w=4e-06 l=1.8e-07 as=1.26e-12 ad=2.16e-12 \
        ps=6.3e-07 pd=5.08e-06 m=(1)*(1)
\+266 (vdd! 52 30 vdd!) pmos1 w=4e-06 l=1.8e-07 as=1.26e-12 ad=2.16e-12 \
        ps=6.3e-07 pd=5.08e-06 m=(1)*(1)
\+265 (Z7 43 vdd! vdd!) pmos1 w=4e-06 l=1.8e-07 as=2.16e-12 ad=1.26e-12 \
        ps=5.08e-06 pd=6.3e-07 m=(1)*(1)
\+264 (30 42 vdd! vdd!) pmos1 w=4e-06 l=1.8e-07 as=2.16e-12 ad=1.26e-12 \
        ps=5.08e-06 pd=6.3e-07 m=(1)*(1)
\+263 (51 50 47 vdd!) pmos1 w=4e-06 l=1.8e-07 as=1.26e-12 ad=2.18e-12 \
        ps=6.3e-07 pd=5.09e-06 m=(1)*(1)
\+262 (vdd! 50 44 vdd!) pmos1 w=4e-06 l=1.8e-07 as=1.26e-12 ad=2.16e-12 \
        ps=6.3e-07 pd=5.08e-06 m=(1)*(1)
\+261 (49 28 vdd! vdd!) pmos1 w=4e-06 l=1.8e-07 as=2.16e-12 ad=2.16e-12 \
        ps=5.08e-06 pd=5.08e-06 m=(1)*(1)
\+260 (48 27 vdd! vdd!) pmos1 w=4e-06 l=1.8e-07 as=2.16e-12 ad=2.16e-12 \
        ps=5.08e-06 pd=5.08e-06 m=(1)*(1)
\+259 (47 45 vdd! vdd!) pmos1 w=4e-06 l=1.8e-07 as=2.14e-12 ad=1.26e-12 \
        ps=5.07e-06 pd=6.3e-07 m=(1)*(1)
\+258 (44 37 vdd! vdd!) pmos1 w=4e-06 l=1.8e-07 as=2.16e-12 ad=1.26e-12 \
        ps=5.08e-06 pd=6.3e-07 m=(1)*(1)
\+257 (vdd! 32 43 vdd!) pmos1 w=4e-06 l=1.8e-07 as=1.26e-12 ad=2.16e-12 \
        ps=6.3e-07 pd=5.08e-06 m=(1)*(1)
\+256 (vdd! 31 42 vdd!) pmos1 w=4e-06 l=1.8e-07 as=1.26e-12 ad=2.16e-12 \
        ps=6.3e-07 pd=5.08e-06 m=(1)*(1)
\+255 (vdd! 32 41 vdd!) pmos1 w=4e-06 l=1.8e-07 as=2.16e-12 ad=2.16e-12 \
        ps=5.08e-06 pd=5.08e-06 m=(1)*(1)
\+254 (vdd! 31 40 vdd!) pmos1 w=4e-06 l=1.8e-07 as=2.16e-12 ad=2.16e-12 \
        ps=5.08e-06 pd=5.08e-06 m=(1)*(1)
\+253 (43 30 vdd! vdd!) pmos1 w=4e-06 l=1.8e-07 as=2.16e-12 ad=1.26e-12 \
        ps=5.08e-06 pd=6.3e-07 m=(1)*(1)
\+252 (42 29 vdd! vdd!) pmos1 w=4e-06 l=1.8e-07 as=2.16e-12 ad=1.26e-12 \
        ps=5.08e-06 pd=6.3e-07 m=(1)*(1)
\+251 (vdd! 44 29 vdd!) pmos1 w=4e-06 l=1.8e-07 as=2.16e-12 ad=2.16e-12 \
        ps=5.08e-06 pd=5.08e-06 m=(1)*(1)
\+250 (45 37 vdd! vdd!) pmos1 w=4e-06 l=1.8e-07 as=2.16e-12 ad=2.16e-12 \
        ps=5.08e-06 pd=5.08e-06 m=(1)*(1)
\+249 (vdd! 41 34 vdd!) pmos1 w=4e-06 l=1.8e-07 as=1.26e-12 ad=2.16e-12 \
        ps=6.3e-07 pd=5.08e-06 m=(1)*(1)
\+248 (vdd! 40 33 vdd!) pmos1 w=4e-06 l=1.8e-07 as=1.26e-12 ad=2.16e-12 \
        ps=6.3e-07 pd=5.08e-06 m=(1)*(1)
\+247 (39 30 vdd! vdd!) pmos1 w=4e-06 l=1.8e-07 as=2.16e-12 ad=2.16e-12 \
        ps=5.08e-06 pd=5.08e-06 m=(1)*(1)
\+246 (38 29 vdd! vdd!) pmos1 w=4e-06 l=1.8e-07 as=2.16e-12 ad=2.16e-12 \
        ps=5.08e-06 pd=5.08e-06 m=(1)*(1)
\+245 (37 22 vdd! vdd!) pmos1 w=4e-06 l=1.8e-07 as=2.16e-12 ad=2.16e-12 \
        ps=5.08e-06 pd=5.08e-06 m=(1)*(1)
\+244 (34 30 28 vdd!) pmos1 w=4e-06 l=1.8e-07 as=2.16e-12 ad=1.26e-12 \
        ps=5.08e-06 pd=6.3e-07 m=(1)*(1)
\+243 (33 29 27 vdd!) pmos1 w=4e-06 l=1.8e-07 as=2.16e-12 ad=1.26e-12 \
        ps=5.08e-06 pd=6.3e-07 m=(1)*(1)
\+242 (Z0 21 vdd! vdd!) pmos1 w=4e-06 l=1.8e-07 as=2.16e-12 ad=2.16e-12 \
        ps=5.08e-06 pd=5.08e-06 m=(1)*(1)
\+241 (32 20 vdd! vdd!) pmos1 w=4e-06 l=1.8e-07 as=2.16e-12 ad=2.16e-12 \
        ps=5.08e-06 pd=5.08e-06 m=(1)*(1)
\+240 (31 19 vdd! vdd!) pmos1 w=4e-06 l=1.8e-07 as=2.16e-12 ad=2.16e-12 \
        ps=5.08e-06 pd=5.08e-06 m=(1)*(1)
\+239 (vdd! X3 22 vdd!) pmos1 w=4e-06 l=1.8e-07 as=1.26e-12 ad=2.16e-12 \
        ps=6.3e-07 pd=5.08e-06 m=(1)*(1)
\+238 (vdd! X0 21 vdd!) pmos1 w=4e-06 l=1.8e-07 as=1.26e-12 ad=2.16e-12 \
        ps=6.3e-07 pd=5.08e-06 m=(1)*(1)
\+237 (28 32 24 vdd!) pmos1 w=4e-06 l=1.8e-07 as=1.26e-12 ad=2.16e-12 \
        ps=6.3e-07 pd=5.08e-06 m=(1)*(1)
\+236 (27 31 23 vdd!) pmos1 w=4e-06 l=1.8e-07 as=1.26e-12 ad=2.16e-12 \
        ps=6.3e-07 pd=5.08e-06 m=(1)*(1)
\+235 (22 Y1 vdd! vdd!) pmos1 w=4e-06 l=1.8e-07 as=2.16e-12 ad=1.26e-12 \
        ps=5.08e-06 pd=6.3e-07 m=(1)*(1)
\+234 (21 Y0 vdd! vdd!) pmos1 w=4e-06 l=1.8e-07 as=2.16e-12 ad=1.26e-12 \
        ps=5.08e-06 pd=6.3e-07 m=(1)*(1)
\+233 (24 39 vdd! vdd!) pmos1 w=4e-06 l=1.8e-07 as=2.16e-12 ad=1.26e-12 \
        ps=5.08e-06 pd=6.3e-07 m=(1)*(1)
\+232 (23 38 vdd! vdd!) pmos1 w=4e-06 l=1.8e-07 as=2.16e-12 ad=1.26e-12 \
        ps=5.08e-06 pd=6.3e-07 m=(1)*(1)
\+231 (vdd! Y3 20 vdd!) pmos1 w=4e-06 l=1.8e-07 as=1.26e-12 ad=2.16e-12 \
        ps=6.3e-07 pd=5.08e-06 m=(1)*(1)
\+230 (vdd! Y2 19 vdd!) pmos1 w=4e-06 l=1.8e-07 as=1.26e-12 ad=2.16e-12 \
        ps=6.3e-07 pd=5.08e-06 m=(1)*(1)
\+229 (20 X3 vdd! vdd!) pmos1 w=4e-06 l=1.8e-07 as=2.16e-12 ad=1.26e-12 \
        ps=5.08e-06 pd=6.3e-07 m=(1)*(1)
\+228 (19 X3 vdd! vdd!) pmos1 w=4e-06 l=1.8e-07 as=2.16e-12 ad=1.26e-12 \
        ps=5.08e-06 pd=6.3e-07 m=(1)*(1)
\+227 (211 X0 257 gnd!) nmos1 w=3.2e-06 l=1.8e-07 as=1.008e-12 \
        ad=1.728e-12 ps=6.3e-07 pd=4.28e-06 m=(1)*(1)
\+226 (212 X0 258 gnd!) nmos1 w=3.2e-06 l=1.8e-07 as=1.008e-12 \
        ad=1.728e-12 ps=6.3e-07 pd=4.28e-06 m=(1)*(1)
\+221 (257 Y2 gnd! gnd!) nmos1 w=3.2e-06 l=1.8e-07 as=1.728e-12 \
        ad=1.008e-12 ps=4.28e-06 pd=6.3e-07 m=(1)*(1)
\+220 (258 Y3 gnd! gnd!) nmos1 w=3.2e-06 l=1.8e-07 as=1.728e-12 \
        ad=1.008e-12 ps=4.28e-06 pd=6.3e-07 m=(1)*(1)
\+219 (gnd! Y1 256 gnd!) nmos1 w=3.2e-06 l=1.8e-07 as=1.008e-12 \
        ad=1.728e-12 ps=6.3e-07 pd=4.28e-06 m=(1)*(1)
\+218 (gnd! X1 255 gnd!) nmos1 w=3.2e-06 l=1.8e-07 as=1.008e-12 \
        ad=1.728e-12 ps=6.3e-07 pd=4.28e-06 m=(1)*(1)
\+213 (256 X0 206 gnd!) nmos1 w=3.2e-06 l=1.8e-07 as=1.728e-12 \
        ad=1.008e-12 ps=4.28e-06 pd=6.3e-07 m=(1)*(1)
\+212 (255 Y0 205 gnd!) nmos1 w=3.2e-06 l=1.8e-07 as=1.728e-12 \
        ad=1.008e-12 ps=4.28e-06 pd=6.3e-07 m=(1)*(1)
\+208 (192 204 254 gnd!) nmos1 w=3.2e-06 l=1.8e-07 as=1.008e-12 \
        ad=1.728e-12 ps=6.3e-07 pd=4.28e-06 m=(1)*(1)
\+207 (191 203 253 gnd!) nmos1 w=3.2e-06 l=1.8e-07 as=1.008e-12 \
        ad=1.728e-12 ps=6.3e-07 pd=4.28e-06 m=(1)*(1)
\+203 (254 132 gnd! gnd!) nmos1 w=3.2e-06 l=1.8e-07 as=1.728e-12 \
        ad=1.008e-12 ps=4.28e-06 pd=6.3e-07 m=(1)*(1)
\+201 (253 145 gnd! gnd!) nmos1 w=3.2e-06 l=1.8e-07 as=1.728e-12 \
        ad=1.008e-12 ps=4.28e-06 pd=6.3e-07 m=(1)*(1)
\+199 (gnd! 198 252 gnd!) nmos1 w=3.2e-06 l=1.8e-07 as=1.008e-12 \
        ad=1.728e-12 ps=6.3e-07 pd=4.28e-06 m=(1)*(1)
\+193 (252 185 190 gnd!) nmos1 w=3.2e-06 l=1.8e-07 as=1.728e-12 \
        ad=1.008e-12 ps=4.28e-06 pd=6.3e-07 m=(1)*(1)
\+188 (183 Y2 250 gnd!) nmos1 w=3.2e-06 l=1.8e-07 as=1.008e-12 \
        ad=1.728e-12 ps=6.3e-07 pd=4.28e-06 m=(1)*(1)
\+187 (184 Y3 251 gnd!) nmos1 w=3.2e-06 l=1.8e-07 as=1.008e-12 \
        ad=1.728e-12 ps=6.3e-07 pd=4.28e-06 m=(1)*(1)
\+186 (gnd! Y1 249 gnd!) nmos1 w=3.2e-06 l=1.8e-07 as=1.008e-12 \
        ad=1.728e-12 ps=6.3e-07 pd=4.28e-06 m=(1)*(1)
\+185 (250 X1 gnd! gnd!) nmos1 w=3.2e-06 l=1.8e-07 as=1.728e-12 \
        ad=1.008e-12 ps=4.28e-06 pd=6.3e-07 m=(1)*(1)
\+184 (251 X1 gnd! gnd!) nmos1 w=3.2e-06 l=1.8e-07 as=1.728e-12 \
        ad=1.008e-12 ps=4.28e-06 pd=6.3e-07 m=(1)*(1)
\+183 (249 X1 186 gnd!) nmos1 w=3.2e-06 l=1.8e-07 as=1.728e-12 \
        ad=1.008e-12 ps=4.28e-06 pd=6.3e-07 m=(1)*(1)
\+171 (gnd! X2 248 gnd!) nmos1 w=3.2e-06 l=1.8e-07 as=1.008e-12 \
        ad=1.728e-12 ps=6.3e-07 pd=4.28e-06 m=(1)*(1)
\+165 (248 Y0 170 gnd!) nmos1 w=3.2e-06 l=1.8e-07 as=1.728e-12 \
        ad=1.008e-12 ps=4.28e-06 pd=6.3e-07 m=(1)*(1)
\+164 (160 109 246 gnd!) nmos1 w=3.2e-06 l=1.8e-07 as=1.008e-12 \
        ad=1.728e-12 ps=6.3e-07 pd=4.28e-06 m=(1)*(1)
\+163 (161 118 247 gnd!) nmos1 w=3.2e-06 l=1.8e-07 as=1.008e-12 \
        ad=1.728e-12 ps=6.3e-07 pd=4.28e-06 m=(1)*(1)
\+158 (246 164 gnd! gnd!) nmos1 w=3.2e-06 l=1.8e-07 as=1.728e-12 \
        ad=1.008e-12 ps=4.28e-06 pd=6.3e-07 m=(1)*(1)
\+157 (247 165 gnd! gnd!) nmos1 w=3.2e-06 l=1.8e-07 as=1.728e-12 \
        ad=1.008e-12 ps=4.28e-06 pd=6.3e-07 m=(1)*(1)
\+153 (149 162 245 gnd!) nmos1 w=3.2e-06 l=1.8e-07 as=1.008e-12 \
        ad=1.728e-12 ps=6.3e-07 pd=4.28e-06 m=(1)*(1)
\+152 (116 160 243 gnd!) nmos1 w=3.2e-06 l=1.8e-07 as=1.008e-12 \
        ad=1.728e-12 ps=6.3e-07 pd=4.28e-06 m=(1)*(1)
\+151 (117 161 244 gnd!) nmos1 w=3.2e-06 l=1.8e-07 as=1.008e-12 \
        ad=1.728e-12 ps=6.3e-07 pd=4.28e-06 m=(1)*(1)
\+149 (245 156 gnd! gnd!) nmos1 w=3.2e-06 l=1.8e-07 as=1.728e-12 \
        ad=1.008e-12 ps=4.28e-06 pd=6.3e-07 m=(1)*(1)
\+148 (243 143 gnd! gnd!) nmos1 w=3.2e-06 l=1.8e-07 as=1.728e-12 \
        ad=1.008e-12 ps=4.28e-06 pd=6.3e-07 m=(1)*(1)
\+147 (244 144 gnd! gnd!) nmos1 w=3.2e-06 l=1.8e-07 as=1.728e-12 \
        ad=1.008e-12 ps=4.28e-06 pd=6.3e-07 m=(1)*(1)
\+141 (108 149 242 gnd!) nmos1 w=3.2e-06 l=1.8e-07 as=1.008e-12 \
        ad=1.728e-12 ps=6.3e-07 pd=4.28e-06 m=(1)*(1)
\+140 (gnd! 147 240 gnd!) nmos1 w=3.2e-06 l=1.8e-07 as=1.008e-12 \
        ad=1.728e-12 ps=6.3e-07 pd=4.28e-06 m=(1)*(1)
\+139 (gnd! 148 241 gnd!) nmos1 w=3.2e-06 l=1.8e-07 as=1.008e-12 \
        ad=1.728e-12 ps=6.3e-07 pd=4.28e-06 m=(1)*(1)
\+138 (242 131 gnd! gnd!) nmos1 w=3.2e-06 l=1.8e-07 as=1.728e-12 \
        ad=1.008e-12 ps=4.28e-06 pd=6.3e-07 m=(1)*(1)
\+137 (240 152 143 gnd!) nmos1 w=3.2e-06 l=1.8e-07 as=1.728e-12 \
        ad=1.008e-12 ps=4.28e-06 pd=6.3e-07 m=(1)*(1)
\+136 (241 153 144 gnd!) nmos1 w=3.2e-06 l=1.8e-07 as=1.728e-12 \
        ad=1.008e-12 ps=4.28e-06 pd=6.3e-07 m=(1)*(1)
\+131 (gnd! 135 239 gnd!) nmos1 w=3.2e-06 l=1.8e-07 as=1.008e-12 \
        ad=1.728e-12 ps=6.3e-07 pd=4.28e-06 m=(1)*(1)
\+126 (239 141 131 gnd!) nmos1 w=3.2e-06 l=1.8e-07 as=1.728e-12 \
        ad=1.008e-12 ps=4.28e-06 pd=6.3e-07 m=(1)*(1)
\+116 (110 83 237 gnd!) nmos1 w=3.2e-06 l=1.8e-07 as=1.008e-12 \
        ad=1.728e-12 ps=6.3e-07 pd=4.28e-06 m=(1)*(1)
\+115 (111 84 238 gnd!) nmos1 w=3.2e-06 l=1.8e-07 as=1.008e-12 \
        ad=1.728e-12 ps=6.3e-07 pd=4.28e-06 m=(1)*(1)
\+112 (237 116 gnd! gnd!) nmos1 w=3.2e-06 l=1.8e-07 as=1.728e-12 \
        ad=1.008e-12 ps=4.28e-06 pd=6.3e-07 m=(1)*(1)
\+111 (238 117 gnd! gnd!) nmos1 w=3.2e-06 l=1.8e-07 as=1.728e-12 \
        ad=1.008e-12 ps=4.28e-06 pd=6.3e-07 m=(1)*(1)
\+107 (103 77 236 gnd!) nmos1 w=3.2e-06 l=1.8e-07 as=1.008e-12 \
        ad=1.728e-12 ps=6.3e-07 pd=4.28e-06 m=(1)*(1)
\+104 (gnd! 110 234 gnd!) nmos1 w=3.2e-06 l=1.8e-07 as=1.008e-12 \
        ad=1.728e-12 ps=6.3e-07 pd=4.28e-06 m=(1)*(1)
\+103 (gnd! 111 235 gnd!) nmos1 w=3.2e-06 l=1.8e-07 as=1.008e-12 \
        ad=1.728e-12 ps=6.3e-07 pd=4.28e-06 m=(1)*(1)
\+102 (236 108 gnd! gnd!) nmos1 w=3.2e-06 l=1.8e-07 as=1.728e-12 \
        ad=1.008e-12 ps=4.28e-06 pd=6.3e-07 m=(1)*(1)
\+100 (234 100 59 gnd!) nmos1 w=3.2e-06 l=1.8e-07 as=1.728e-12 \
        ad=1.008e-12 ps=4.28e-06 pd=6.3e-07 m=(1)*(1)
\+99 (235 101 60 gnd!) nmos1 w=3.2e-06 l=1.8e-07 as=1.728e-12 ad=1.008e-12 \
        ps=4.28e-06 pd=6.3e-07 m=(1)*(1)
\+95 (gnd! 103 233 gnd!) nmos1 w=3.2e-06 l=1.8e-07 as=1.008e-12 \
        ad=1.728e-12 ps=6.3e-07 pd=4.28e-06 m=(1)*(1)
\+94 (gnd! 51 231 gnd!) nmos1 w=3.2e-06 l=1.8e-07 as=1.008e-12 \
        ad=1.728e-12 ps=6.3e-07 pd=4.28e-06 m=(1)*(1)
\+93 (gnd! 63 232 gnd!) nmos1 w=3.2e-06 l=1.8e-07 as=1.008e-12 \
        ad=1.728e-12 ps=6.3e-07 pd=4.28e-06 m=(1)*(1)
\+92 (233 91 50 gnd!) nmos1 w=3.2e-06 l=1.8e-07 as=1.728e-12 ad=1.008e-12 \
        ps=4.28e-06 pd=6.3e-07 m=(1)*(1)
\+88 (232 86 101 gnd!) nmos1 w=3.2e-06 l=1.8e-07 as=1.728e-12 ad=1.008e-12 \
        ps=4.28e-06 pd=6.3e-07 m=(1)*(1)
\+87 (231 85 100 gnd!) nmos1 w=3.2e-06 l=1.8e-07 as=1.728e-12 ad=1.008e-12 \
        ps=4.28e-06 pd=6.3e-07 m=(1)*(1)
\+86 (gnd! 82 230 gnd!) nmos1 w=3.2e-06 l=1.8e-07 as=1.008e-12 \
        ad=1.728e-12 ps=6.3e-07 pd=4.28e-06 m=(1)*(1)
\+80 (230 71 91 gnd!) nmos1 w=3.2e-06 l=1.8e-07 as=1.728e-12 ad=1.008e-12 \
        ps=4.28e-06 pd=6.3e-07 m=(1)*(1)
\+66 (gnd! X2 229 gnd!) nmos1 w=3.2e-06 l=1.8e-07 as=1.008e-12 \
        ad=1.728e-12 ps=6.3e-07 pd=4.28e-06 m=(1)*(1)
\+65 (gnd! X2 228 gnd!) nmos1 w=3.2e-06 l=1.8e-07 as=1.008e-12 \
        ad=1.728e-12 ps=6.3e-07 pd=4.28e-06 m=(1)*(1)
\+63 (228 Y2 73 gnd!) nmos1 w=3.2e-06 l=1.8e-07 as=1.728e-12 ad=1.008e-12 \
        ps=4.28e-06 pd=6.3e-07 m=(1)*(1)
\+62 (229 Y3 74 gnd!) nmos1 w=3.2e-06 l=1.8e-07 as=1.728e-12 ad=1.008e-12 \
        ps=4.28e-06 pd=6.3e-07 m=(1)*(1)
\+61 (gnd! Y1 227 gnd!) nmos1 w=3.2e-06 l=1.8e-07 as=1.008e-12 \
        ad=1.728e-12 ps=6.3e-07 pd=4.28e-06 m=(1)*(1)
\+60 (227 X2 72 gnd!) nmos1 w=3.2e-06 l=1.8e-07 as=1.728e-12 ad=1.008e-12 \
        ps=4.28e-06 pd=6.3e-07 m=(1)*(1)
\+51 (52 27 225 gnd!) nmos1 w=3.2e-06 l=1.8e-07 as=1.008e-12 ad=1.728e-12 \
        ps=6.3e-07 pd=4.28e-06 m=(1)*(1)
\+50 (53 28 226 gnd!) nmos1 w=3.2e-06 l=1.8e-07 as=1.008e-12 ad=1.728e-12 \
        ps=6.3e-07 pd=4.28e-06 m=(1)*(1)
\+49 (gnd! X3 224 gnd!) nmos1 w=3.2e-06 l=1.8e-07 as=1.008e-12 \
        ad=1.728e-12 ps=6.3e-07 pd=4.28e-06 m=(1)*(1)
\+47 (225 59 gnd! gnd!) nmos1 w=3.2e-06 l=1.8e-07 as=1.728e-12 \
        ad=1.008e-12 ps=4.28e-06 pd=6.3e-07 m=(1)*(1)
\+46 (226 60 gnd! gnd!) nmos1 w=3.2e-06 l=1.8e-07 as=1.728e-12 \
        ad=1.008e-12 ps=4.28e-06 pd=6.3e-07 m=(1)*(1)
\+45 (224 Y0 56 gnd!) nmos1 w=3.2e-06 l=1.8e-07 as=1.728e-12 ad=1.008e-12 \
        ps=4.28e-06 pd=6.3e-07 m=(1)*(1)
\+39 (gnd! 52 222 gnd!) nmos1 w=3.2e-06 l=1.8e-07 as=1.008e-12 \
        ad=1.728e-12 ps=6.3e-07 pd=4.28e-06 m=(1)*(1)
\+38 (gnd! 53 223 gnd!) nmos1 w=3.2e-06 l=1.8e-07 as=1.008e-12 \
        ad=1.728e-12 ps=6.3e-07 pd=4.28e-06 m=(1)*(1)
\+37 (222 42 30 gnd!) nmos1 w=3.2e-06 l=1.8e-07 as=1.728e-12 ad=1.008e-12 \
        ps=4.28e-06 pd=6.3e-07 m=(1)*(1)
\+36 (223 43 Z7 gnd!) nmos1 w=3.2e-06 l=1.8e-07 as=1.728e-12 ad=1.008e-12 \
        ps=4.28e-06 pd=6.3e-07 m=(1)*(1)
\+35 (44 50 221 gnd!) nmos1 w=3.2e-06 l=1.8e-07 as=1.008e-12 ad=1.728e-12 \
        ps=6.3e-07 pd=4.28e-06 m=(1)*(1)
\+31 (221 37 gnd! gnd!) nmos1 w=3.2e-06 l=1.8e-07 as=1.728e-12 \
        ad=1.008e-12 ps=4.28e-06 pd=6.3e-07 m=(1)*(1)
\+29 (gnd! 31 219 gnd!) nmos1 w=3.2e-06 l=1.8e-07 as=1.008e-12 \
        ad=1.728e-12 ps=6.3e-07 pd=4.28e-06 m=(1)*(1)
\+28 (gnd! 32 220 gnd!) nmos1 w=3.2e-06 l=1.8e-07 as=1.008e-12 \
        ad=1.728e-12 ps=6.3e-07 pd=4.28e-06 m=(1)*(1)
\+25 (219 29 42 gnd!) nmos1 w=3.2e-06 l=1.8e-07 as=1.728e-12 ad=1.008e-12 \
        ps=4.28e-06 pd=6.3e-07 m=(1)*(1)
\+24 (220 30 43 gnd!) nmos1 w=3.2e-06 l=1.8e-07 as=1.728e-12 ad=1.008e-12 \
        ps=4.28e-06 pd=6.3e-07 m=(1)*(1)
\+11 (gnd! X3 218 gnd!) nmos1 w=3.2e-06 l=1.8e-07 as=1.008e-12 \
        ad=1.728e-12 ps=6.3e-07 pd=4.28e-06 m=(1)*(1)
\+10 (gnd! X0 217 gnd!) nmos1 w=3.2e-06 l=1.8e-07 as=1.008e-12 \
        ad=1.728e-12 ps=6.3e-07 pd=4.28e-06 m=(1)*(1)
\+7 (218 Y1 22 gnd!) nmos1 w=3.2e-06 l=1.8e-07 as=1.728e-12 ad=1.008e-12 \
        ps=4.28e-06 pd=6.3e-07 m=(1)*(1)
\+6 (217 Y0 21 gnd!) nmos1 w=3.2e-06 l=1.8e-07 as=1.728e-12 ad=1.008e-12 \
        ps=4.28e-06 pd=6.3e-07 m=(1)*(1)
\+3 (gnd! Y3 216 gnd!) nmos1 w=3.2e-06 l=1.8e-07 as=1.008e-12 ad=1.728e-12 \
        ps=6.3e-07 pd=4.28e-06 m=(1)*(1)
\+2 (gnd! Y2 215 gnd!) nmos1 w=3.2e-06 l=1.8e-07 as=1.008e-12 ad=1.728e-12 \
        ps=6.3e-07 pd=4.28e-06 m=(1)*(1)
\+1 (216 X3 20 gnd!) nmos1 w=3.2e-06 l=1.8e-07 as=1.728e-12 ad=1.008e-12 \
        ps=4.28e-06 pd=6.3e-07 m=(1)*(1)
\+0 (215 X3 19 gnd!) nmos1 w=3.2e-06 l=1.8e-07 as=1.728e-12 ad=1.008e-12 \
        ps=4.28e-06 pd=6.3e-07 m=(1)*(1)
\+225 (185 206 gnd! gnd!) nmos1 w=1.6e-06 l=1.8e-07 as=8.64e-13 \
        ad=8.64e-13 ps=2.68e-06 pd=2.68e-06 m=(1)*(1)
\+224 (198 205 gnd! gnd!) nmos1 w=1.6e-06 l=1.8e-07 as=8.64e-13 \
        ad=8.64e-13 ps=2.68e-06 pd=2.68e-06 m=(1)*(1)
\+223 (gnd! 204 214 gnd!) nmos1 w=1.6e-06 l=1.8e-07 as=8.64e-13 \
        ad=8.64e-13 ps=2.68e-06 pd=2.68e-06 m=(1)*(1)
\+222 (gnd! 203 213 gnd!) nmos1 w=1.6e-06 l=1.8e-07 as=8.64e-13 \
        ad=8.64e-13 ps=2.68e-06 pd=2.68e-06 m=(1)*(1)
\+217 (gnd! 132 210 gnd!) nmos1 w=1.6e-06 l=1.8e-07 as=5e-13 ad=8.72e-13 \
        ps=6.25e-07 pd=2.69e-06 m=(1)*(1)
\+216 (gnd! 145 208 gnd!) nmos1 w=1.6e-06 l=1.8e-07 as=5e-13 ad=8.72e-13 \
        ps=6.25e-07 pd=2.69e-06 m=(1)*(1)
\+215 (gnd! 211 204 gnd!) nmos1 w=1.6e-06 l=1.8e-07 as=8.64e-13 \
        ad=8.64e-13 ps=2.68e-06 pd=2.68e-06 m=(1)*(1)
\+214 (gnd! 212 203 gnd!) nmos1 w=1.6e-06 l=1.8e-07 as=8.64e-13 \
        ad=8.64e-13 ps=2.68e-06 pd=2.68e-06 m=(1)*(1)
\+211 (210 204 Z2 gnd!) nmos1 w=1.6e-06 l=1.8e-07 as=8.64e-13 ad=5e-13 \
        ps=2.68e-06 pd=6.25e-07 m=(1)*(1)
\+210 (208 203 Z3 gnd!) nmos1 w=1.6e-06 l=1.8e-07 as=8.64e-13 ad=5e-13 \
        ps=2.68e-06 pd=6.25e-07 m=(1)*(1)
\+209 (Z2 214 201 gnd!) nmos1 w=1.6e-06 l=1.8e-07 as=5.04e-13 ad=8.64e-13 \
        ps=6.3e-07 pd=2.68e-06 m=(1)*(1)
\+206 (Z3 213 199 gnd!) nmos1 w=1.6e-06 l=1.8e-07 as=5.04e-13 ad=8.64e-13 \
        ps=6.3e-07 pd=2.68e-06 m=(1)*(1)
\+205 (gnd! 198 197 gnd!) nmos1 w=1.6e-06 l=1.8e-07 as=8.64e-13 \
        ad=8.64e-13 ps=2.68e-06 pd=2.68e-06 m=(1)*(1)
\+204 (135 190 gnd! gnd!) nmos1 w=1.6e-06 l=1.8e-07 as=8.64e-13 \
        ad=8.64e-13 ps=2.68e-06 pd=2.68e-06 m=(1)*(1)
\+202 (201 196 gnd! gnd!) nmos1 w=1.6e-06 l=1.8e-07 as=8.64e-13 \
        ad=5.04e-13 ps=2.68e-06 pd=6.3e-07 m=(1)*(1)
\+200 (199 195 gnd! gnd!) nmos1 w=1.6e-06 l=1.8e-07 as=8.64e-13 \
        ad=5.04e-13 ps=2.68e-06 pd=6.3e-07 m=(1)*(1)
\+198 (gnd! 197 194 gnd!) nmos1 w=1.6e-06 l=1.8e-07 as=5.04e-13 \
        ad=8.64e-13 ps=6.3e-07 pd=2.68e-06 m=(1)*(1)
\+197 (gnd! 192 147 gnd!) nmos1 w=1.6e-06 l=1.8e-07 as=8.64e-13 \
        ad=8.64e-13 ps=2.68e-06 pd=2.68e-06 m=(1)*(1)
\+196 (196 132 gnd! gnd!) nmos1 w=1.6e-06 l=1.8e-07 as=8.64e-13 \
        ad=8.64e-13 ps=2.68e-06 pd=2.68e-06 m=(1)*(1)
\+195 (gnd! 191 148 gnd!) nmos1 w=1.6e-06 l=1.8e-07 as=8.64e-13 \
        ad=8.64e-13 ps=2.68e-06 pd=2.68e-06 m=(1)*(1)
\+194 (195 145 gnd! gnd!) nmos1 w=1.6e-06 l=1.8e-07 as=8.64e-13 \
        ad=8.64e-13 ps=2.68e-06 pd=2.68e-06 m=(1)*(1)
\+192 (194 187 Z1 gnd!) nmos1 w=1.6e-06 l=1.8e-07 as=8.64e-13 ad=5.04e-13 \
        ps=2.68e-06 pd=6.3e-07 m=(1)*(1)
\+191 (162 186 gnd! gnd!) nmos1 w=1.6e-06 l=1.8e-07 as=8.64e-13 \
        ad=8.64e-13 ps=2.68e-06 pd=2.68e-06 m=(1)*(1)
\+190 (Z1 185 189 gnd!) nmos1 w=1.6e-06 l=1.8e-07 as=5e-13 ad=8.64e-13 \
        ps=6.25e-07 pd=2.68e-06 m=(1)*(1)
\+189 (189 198 gnd! gnd!) nmos1 w=1.6e-06 l=1.8e-07 as=8.72e-13 ad=5e-13 \
        ps=2.69e-06 pd=6.25e-07 m=(1)*(1)
\+182 (187 185 gnd! gnd!) nmos1 w=1.6e-06 l=1.8e-07 as=8.64e-13 \
        ad=8.64e-13 ps=2.68e-06 pd=2.68e-06 m=(1)*(1)
\+181 (gnd! 164 180 gnd!) nmos1 w=1.6e-06 l=1.8e-07 as=5e-13 ad=8.72e-13 \
        ps=6.25e-07 pd=2.69e-06 m=(1)*(1)
\+180 (gnd! 165 182 gnd!) nmos1 w=1.6e-06 l=1.8e-07 as=5e-13 ad=8.72e-13 \
        ps=6.25e-07 pd=2.69e-06 m=(1)*(1)
\+179 (180 109 152 gnd!) nmos1 w=1.6e-06 l=1.8e-07 as=8.64e-13 ad=5e-13 \
        ps=2.68e-06 pd=6.25e-07 m=(1)*(1)
\+178 (182 118 153 gnd!) nmos1 w=1.6e-06 l=1.8e-07 as=8.64e-13 ad=5e-13 \
        ps=2.68e-06 pd=6.25e-07 m=(1)*(1)
\+177 (gnd! 183 164 gnd!) nmos1 w=1.6e-06 l=1.8e-07 as=8.64e-13 \
        ad=8.64e-13 ps=2.68e-06 pd=2.68e-06 m=(1)*(1)
\+176 (gnd! 184 165 gnd!) nmos1 w=1.6e-06 l=1.8e-07 as=8.64e-13 \
        ad=8.64e-13 ps=2.68e-06 pd=2.68e-06 m=(1)*(1)
\+175 (156 170 gnd! gnd!) nmos1 w=1.6e-06 l=1.8e-07 as=8.64e-13 \
        ad=8.64e-13 ps=2.68e-06 pd=2.68e-06 m=(1)*(1)
\+174 (gnd! 156 178 gnd!) nmos1 w=1.6e-06 l=1.8e-07 as=5e-13 ad=8.72e-13 \
        ps=6.25e-07 pd=2.69e-06 m=(1)*(1)
\+173 (152 171 174 gnd!) nmos1 w=1.6e-06 l=1.8e-07 as=5.04e-13 ad=8.64e-13 \
        ps=6.3e-07 pd=2.68e-06 m=(1)*(1)
\+172 (153 172 176 gnd!) nmos1 w=1.6e-06 l=1.8e-07 as=5.04e-13 ad=8.64e-13 \
        ps=6.3e-07 pd=2.68e-06 m=(1)*(1)
\+170 (178 162 141 gnd!) nmos1 w=1.6e-06 l=1.8e-07 as=8.64e-13 ad=5e-13 \
        ps=2.68e-06 pd=6.25e-07 m=(1)*(1)
\+169 (gnd! 109 171 gnd!) nmos1 w=1.6e-06 l=1.8e-07 as=8.64e-13 \
        ad=8.64e-13 ps=2.68e-06 pd=2.68e-06 m=(1)*(1)
\+168 (gnd! 118 172 gnd!) nmos1 w=1.6e-06 l=1.8e-07 as=8.64e-13 \
        ad=8.64e-13 ps=2.68e-06 pd=2.68e-06 m=(1)*(1)
\+167 (174 168 gnd! gnd!) nmos1 w=1.6e-06 l=1.8e-07 as=8.64e-13 \
        ad=5.04e-13 ps=2.68e-06 pd=6.3e-07 m=(1)*(1)
\+166 (176 169 gnd! gnd!) nmos1 w=1.6e-06 l=1.8e-07 as=8.64e-13 \
        ad=5.04e-13 ps=2.68e-06 pd=6.3e-07 m=(1)*(1)
\+162 (141 163 167 gnd!) nmos1 w=1.6e-06 l=1.8e-07 as=5.04e-13 ad=8.64e-13 \
        ps=6.3e-07 pd=2.68e-06 m=(1)*(1)
\+161 (168 164 gnd! gnd!) nmos1 w=1.6e-06 l=1.8e-07 as=8.64e-13 \
        ad=8.64e-13 ps=2.68e-06 pd=2.68e-06 m=(1)*(1)
\+160 (169 165 gnd! gnd!) nmos1 w=1.6e-06 l=1.8e-07 as=8.64e-13 \
        ad=8.64e-13 ps=2.68e-06 pd=2.68e-06 m=(1)*(1)
\+159 (gnd! 162 163 gnd!) nmos1 w=1.6e-06 l=1.8e-07 as=8.64e-13 \
        ad=8.64e-13 ps=2.68e-06 pd=2.68e-06 m=(1)*(1)
\+156 (167 159 gnd! gnd!) nmos1 w=1.6e-06 l=1.8e-07 as=8.64e-13 \
        ad=5.04e-13 ps=2.68e-06 pd=6.3e-07 m=(1)*(1)
\+155 (gnd! 152 157 gnd!) nmos1 w=1.6e-06 l=1.8e-07 as=8.64e-13 \
        ad=8.64e-13 ps=2.68e-06 pd=2.68e-06 m=(1)*(1)
\+154 (gnd! 153 158 gnd!) nmos1 w=1.6e-06 l=1.8e-07 as=8.64e-13 \
        ad=8.64e-13 ps=2.68e-06 pd=2.68e-06 m=(1)*(1)
\+150 (159 156 gnd! gnd!) nmos1 w=1.6e-06 l=1.8e-07 as=8.64e-13 \
        ad=8.64e-13 ps=2.68e-06 pd=2.68e-06 m=(1)*(1)
\+146 (gnd! 147 154 gnd!) nmos1 w=1.6e-06 l=1.8e-07 as=5e-13 ad=8.72e-13 \
        ps=6.25e-07 pd=2.69e-06 m=(1)*(1)
\+145 (gnd! 148 155 gnd!) nmos1 w=1.6e-06 l=1.8e-07 as=5e-13 ad=8.72e-13 \
        ps=6.25e-07 pd=2.69e-06 m=(1)*(1)
\+144 (gnd! 141 146 gnd!) nmos1 w=1.6e-06 l=1.8e-07 as=8.64e-13 \
        ad=8.64e-13 ps=2.68e-06 pd=2.68e-06 m=(1)*(1)
\+143 (155 153 Z4 gnd!) nmos1 w=1.6e-06 l=1.8e-07 as=8.64e-13 ad=5e-13 \
        ps=2.68e-06 pd=6.25e-07 m=(1)*(1)
\+142 (154 152 145 gnd!) nmos1 w=1.6e-06 l=1.8e-07 as=8.64e-13 ad=5e-13 \
        ps=2.68e-06 pd=6.25e-07 m=(1)*(1)
\+135 (gnd! 135 142 gnd!) nmos1 w=1.6e-06 l=1.8e-07 as=5e-13 ad=8.72e-13 \
        ps=6.25e-07 pd=2.69e-06 m=(1)*(1)
\+134 (145 157 137 gnd!) nmos1 w=1.6e-06 l=1.8e-07 as=5.04e-13 ad=8.64e-13 \
        ps=6.3e-07 pd=2.68e-06 m=(1)*(1)
\+133 (Z4 158 139 gnd!) nmos1 w=1.6e-06 l=1.8e-07 as=5.04e-13 ad=8.64e-13 \
        ps=6.3e-07 pd=2.68e-06 m=(1)*(1)
\+132 (142 141 132 gnd!) nmos1 w=1.6e-06 l=1.8e-07 as=8.64e-13 ad=5e-13 \
        ps=2.68e-06 pd=6.25e-07 m=(1)*(1)
\+130 (137 133 gnd! gnd!) nmos1 w=1.6e-06 l=1.8e-07 as=8.64e-13 \
        ad=5.04e-13 ps=2.68e-06 pd=6.3e-07 m=(1)*(1)
\+129 (139 134 gnd! gnd!) nmos1 w=1.6e-06 l=1.8e-07 as=8.64e-13 \
        ad=5.04e-13 ps=2.68e-06 pd=6.3e-07 m=(1)*(1)
\+128 (gnd! 147 133 gnd!) nmos1 w=1.6e-06 l=1.8e-07 as=8.64e-13 \
        ad=8.64e-13 ps=2.68e-06 pd=2.68e-06 m=(1)*(1)
\+127 (gnd! 148 134 gnd!) nmos1 w=1.6e-06 l=1.8e-07 as=8.64e-13 \
        ad=8.64e-13 ps=2.68e-06 pd=2.68e-06 m=(1)*(1)
\+125 (132 146 130 gnd!) nmos1 w=1.6e-06 l=1.8e-07 as=5.04e-13 ad=8.64e-13 \
        ps=6.3e-07 pd=2.68e-06 m=(1)*(1)
\+124 (130 126 gnd! gnd!) nmos1 w=1.6e-06 l=1.8e-07 as=8.64e-13 \
        ad=5.04e-13 ps=2.68e-06 pd=6.3e-07 m=(1)*(1)
\+123 (gnd! 135 126 gnd!) nmos1 w=1.6e-06 l=1.8e-07 as=8.64e-13 \
        ad=8.64e-13 ps=2.68e-06 pd=2.68e-06 m=(1)*(1)
\+122 (127 116 gnd! gnd!) nmos1 w=1.6e-06 l=1.8e-07 as=8.64e-13 \
        ad=8.64e-13 ps=2.68e-06 pd=2.68e-06 m=(1)*(1)
\+121 (128 117 gnd! gnd!) nmos1 w=1.6e-06 l=1.8e-07 as=8.64e-13 \
        ad=8.64e-13 ps=2.68e-06 pd=2.68e-06 m=(1)*(1)
\+120 (gnd! 127 124 gnd!) nmos1 w=1.6e-06 l=1.8e-07 as=5.04e-13 \
        ad=8.64e-13 ps=6.3e-07 pd=2.68e-06 m=(1)*(1)
\+119 (gnd! 128 125 gnd!) nmos1 w=1.6e-06 l=1.8e-07 as=5.04e-13 \
        ad=8.64e-13 ps=6.3e-07 pd=2.68e-06 m=(1)*(1)
\+118 (124 104 118 gnd!) nmos1 w=1.6e-06 l=1.8e-07 as=8.64e-13 ad=5.04e-13 \
        ps=2.68e-06 pd=6.3e-07 m=(1)*(1)
\+117 (125 105 Z5 gnd!) nmos1 w=1.6e-06 l=1.8e-07 as=8.64e-13 ad=5.04e-13 \
        ps=2.68e-06 pd=6.3e-07 m=(1)*(1)
\+114 (121 108 gnd! gnd!) nmos1 w=1.6e-06 l=1.8e-07 as=8.64e-13 \
        ad=8.64e-13 ps=2.68e-06 pd=2.68e-06 m=(1)*(1)
\+113 (gnd! 121 120 gnd!) nmos1 w=1.6e-06 l=1.8e-07 as=5.04e-13 \
        ad=8.64e-13 ps=6.3e-07 pd=2.68e-06 m=(1)*(1)
\+110 (120 102 109 gnd!) nmos1 w=1.6e-06 l=1.8e-07 as=8.64e-13 ad=5.04e-13 \
        ps=2.68e-06 pd=6.3e-07 m=(1)*(1)
\+109 (118 83 112 gnd!) nmos1 w=1.6e-06 l=1.8e-07 as=5e-13 ad=8.64e-13 \
        ps=6.25e-07 pd=2.68e-06 m=(1)*(1)
\+108 (Z5 84 113 gnd!) nmos1 w=1.6e-06 l=1.8e-07 as=5e-13 ad=8.64e-13 \
        ps=6.25e-07 pd=2.68e-06 m=(1)*(1)
\+106 (112 116 gnd! gnd!) nmos1 w=1.6e-06 l=1.8e-07 as=8.72e-13 ad=5e-13 \
        ps=2.69e-06 pd=6.25e-07 m=(1)*(1)
\+105 (113 117 gnd! gnd!) nmos1 w=1.6e-06 l=1.8e-07 as=8.72e-13 ad=5e-13 \
        ps=2.69e-06 pd=6.25e-07 m=(1)*(1)
\+101 (109 77 106 gnd!) nmos1 w=1.6e-06 l=1.8e-07 as=5e-13 ad=8.64e-13 \
        ps=6.25e-07 pd=2.68e-06 m=(1)*(1)
\+98 (106 108 gnd! gnd!) nmos1 w=1.6e-06 l=1.8e-07 as=8.72e-13 ad=5e-13 \
        ps=2.69e-06 pd=6.25e-07 m=(1)*(1)
\+97 (104 83 gnd! gnd!) nmos1 w=1.6e-06 l=1.8e-07 as=8.64e-13 ad=8.64e-13 \
        ps=2.68e-06 pd=2.68e-06 m=(1)*(1)
\+96 (105 84 gnd! gnd!) nmos1 w=1.6e-06 l=1.8e-07 as=8.64e-13 ad=8.64e-13 \
        ps=2.68e-06 pd=2.68e-06 m=(1)*(1)
\+91 (gnd! 51 98 gnd!) nmos1 w=1.6e-06 l=1.8e-07 as=8.64e-13 ad=8.64e-13 \
        ps=2.68e-06 pd=2.68e-06 m=(1)*(1)
\+90 (gnd! 63 99 gnd!) nmos1 w=1.6e-06 l=1.8e-07 as=8.64e-13 ad=8.64e-13 \
        ps=2.68e-06 pd=2.68e-06 m=(1)*(1)
\+89 (102 77 gnd! gnd!) nmos1 w=1.6e-06 l=1.8e-07 as=8.64e-13 ad=8.64e-13 \
        ps=2.68e-06 pd=2.68e-06 m=(1)*(1)
\+85 (gnd! 98 94 gnd!) nmos1 w=1.6e-06 l=1.8e-07 as=5.04e-13 ad=8.64e-13 \
        ps=6.3e-07 pd=2.68e-06 m=(1)*(1)
\+84 (gnd! 99 95 gnd!) nmos1 w=1.6e-06 l=1.8e-07 as=5.04e-13 ad=8.64e-13 \
        ps=6.3e-07 pd=2.68e-06 m=(1)*(1)
\+83 (gnd! 82 90 gnd!) nmos1 w=1.6e-06 l=1.8e-07 as=8.64e-13 ad=8.64e-13 \
        ps=2.68e-06 pd=2.68e-06 m=(1)*(1)
\+82 (96 85 gnd! gnd!) nmos1 w=1.6e-06 l=1.8e-07 as=8.64e-13 ad=8.64e-13 \
        ps=2.68e-06 pd=2.68e-06 m=(1)*(1)
\+81 (97 86 gnd! gnd!) nmos1 w=1.6e-06 l=1.8e-07 as=8.64e-13 ad=8.64e-13 \
        ps=2.68e-06 pd=2.68e-06 m=(1)*(1)
\+79 (94 96 83 gnd!) nmos1 w=1.6e-06 l=1.8e-07 as=8.64e-13 ad=5.04e-13 \
        ps=2.68e-06 pd=6.3e-07 m=(1)*(1)
\+78 (95 97 84 gnd!) nmos1 w=1.6e-06 l=1.8e-07 as=8.64e-13 ad=5.04e-13 \
        ps=2.68e-06 pd=6.3e-07 m=(1)*(1)
\+77 (gnd! 90 88 gnd!) nmos1 w=1.6e-06 l=1.8e-07 as=5.04e-13 ad=8.64e-13 \
        ps=6.3e-07 pd=2.68e-06 m=(1)*(1)
\+76 (89 71 gnd! gnd!) nmos1 w=1.6e-06 l=1.8e-07 as=8.64e-13 ad=8.64e-13 \
        ps=2.68e-06 pd=2.68e-06 m=(1)*(1)
\+75 (88 89 77 gnd!) nmos1 w=1.6e-06 l=1.8e-07 as=8.64e-13 ad=5.04e-13 \
        ps=2.68e-06 pd=6.3e-07 m=(1)*(1)
\+74 (85 73 gnd! gnd!) nmos1 w=1.6e-06 l=1.8e-07 as=8.64e-13 ad=8.64e-13 \
        ps=2.68e-06 pd=2.68e-06 m=(1)*(1)
\+73 (86 74 gnd! gnd!) nmos1 w=1.6e-06 l=1.8e-07 as=8.64e-13 ad=8.64e-13 \
        ps=2.68e-06 pd=2.68e-06 m=(1)*(1)
\+72 (83 85 80 gnd!) nmos1 w=1.6e-06 l=1.8e-07 as=5e-13 ad=8.64e-13 \
        ps=6.25e-07 pd=2.68e-06 m=(1)*(1)
\+71 (84 86 81 gnd!) nmos1 w=1.6e-06 l=1.8e-07 as=5e-13 ad=8.64e-13 \
        ps=6.25e-07 pd=2.68e-06 m=(1)*(1)
\+70 (82 72 gnd! gnd!) nmos1 w=1.6e-06 l=1.8e-07 as=8.64e-13 ad=8.64e-13 \
        ps=2.68e-06 pd=2.68e-06 m=(1)*(1)
\+69 (80 51 gnd! gnd!) nmos1 w=1.6e-06 l=1.8e-07 as=8.72e-13 ad=5e-13 \
        ps=2.69e-06 pd=6.25e-07 m=(1)*(1)
\+68 (81 63 gnd! gnd!) nmos1 w=1.6e-06 l=1.8e-07 as=8.72e-13 ad=5e-13 \
        ps=2.69e-06 pd=6.25e-07 m=(1)*(1)
\+67 (77 71 76 gnd!) nmos1 w=1.6e-06 l=1.8e-07 as=5e-13 ad=8.64e-13 \
        ps=6.25e-07 pd=2.68e-06 m=(1)*(1)
\+64 (76 82 gnd! gnd!) nmos1 w=1.6e-06 l=1.8e-07 as=8.72e-13 ad=5e-13 \
        ps=2.69e-06 pd=6.25e-07 m=(1)*(1)
\+59 (71 56 gnd! gnd!) nmos1 w=1.6e-06 l=1.8e-07 as=8.64e-13 ad=8.64e-13 \
        ps=2.68e-06 pd=2.68e-06 m=(1)*(1)
\+58 (69 59 gnd! gnd!) nmos1 w=1.6e-06 l=1.8e-07 as=8.64e-13 ad=8.64e-13 \
        ps=2.68e-06 pd=2.68e-06 m=(1)*(1)
\+57 (70 60 gnd! gnd!) nmos1 w=1.6e-06 l=1.8e-07 as=8.64e-13 ad=8.64e-13 \
        ps=2.68e-06 pd=2.68e-06 m=(1)*(1)
\+56 (gnd! 69 67 gnd!) nmos1 w=1.6e-06 l=1.8e-07 as=5.04e-13 ad=8.64e-13 \
        ps=6.3e-07 pd=2.68e-06 m=(1)*(1)
\+55 (gnd! 70 68 gnd!) nmos1 w=1.6e-06 l=1.8e-07 as=5.04e-13 ad=8.64e-13 \
        ps=6.3e-07 pd=2.68e-06 m=(1)*(1)
\+54 (gnd! 50 64 gnd!) nmos1 w=1.6e-06 l=1.8e-07 as=8.64e-13 ad=8.64e-13 \
        ps=2.68e-06 pd=2.68e-06 m=(1)*(1)
\+53 (67 48 63 gnd!) nmos1 w=1.6e-06 l=1.8e-07 as=8.64e-13 ad=5.04e-13 \
        ps=2.68e-06 pd=6.3e-07 m=(1)*(1)
\+52 (68 49 Z6 gnd!) nmos1 w=1.6e-06 l=1.8e-07 as=8.64e-13 ad=5.04e-13 \
        ps=2.68e-06 pd=6.3e-07 m=(1)*(1)
\+48 (gnd! 37 62 gnd!) nmos1 w=1.6e-06 l=1.8e-07 as=5e-13 ad=8.72e-13 \
        ps=6.25e-07 pd=2.69e-06 m=(1)*(1)
\+44 (Z6 28 55 gnd!) nmos1 w=1.6e-06 l=1.8e-07 as=5e-13 ad=8.64e-13 \
        ps=6.25e-07 pd=2.68e-06 m=(1)*(1)
\+43 (63 27 54 gnd!) nmos1 w=1.6e-06 l=1.8e-07 as=5e-13 ad=8.64e-13 \
        ps=6.25e-07 pd=2.68e-06 m=(1)*(1)
\+42 (62 50 51 gnd!) nmos1 w=1.6e-06 l=1.8e-07 as=8.64e-13 ad=5e-13 \
        ps=2.68e-06 pd=6.25e-07 m=(1)*(1)
\+41 (54 59 gnd! gnd!) nmos1 w=1.6e-06 l=1.8e-07 as=8.72e-13 ad=5e-13 \
        ps=2.69e-06 pd=6.25e-07 m=(1)*(1)
\+40 (55 60 gnd! gnd!) nmos1 w=1.6e-06 l=1.8e-07 as=8.72e-13 ad=5e-13 \
        ps=2.69e-06 pd=6.25e-07 m=(1)*(1)
\+34 (51 64 46 gnd!) nmos1 w=1.6e-06 l=1.8e-07 as=5.04e-13 ad=8.64e-13 \
        ps=6.3e-07 pd=2.68e-06 m=(1)*(1)
\+33 (49 28 gnd! gnd!) nmos1 w=1.6e-06 l=1.8e-07 as=8.64e-13 ad=8.64e-13 \
        ps=2.68e-06 pd=2.68e-06 m=(1)*(1)
\+32 (48 27 gnd! gnd!) nmos1 w=1.6e-06 l=1.8e-07 as=8.64e-13 ad=8.64e-13 \
        ps=2.68e-06 pd=2.68e-06 m=(1)*(1)
\+30 (46 45 gnd! gnd!) nmos1 w=1.6e-06 l=1.8e-07 as=8.64e-13 ad=5.04e-13 \
        ps=2.68e-06 pd=6.3e-07 m=(1)*(1)
\+27 (gnd! 31 40 gnd!) nmos1 w=1.6e-06 l=1.8e-07 as=8.64e-13 ad=8.64e-13 \
        ps=2.68e-06 pd=2.68e-06 m=(1)*(1)
\+26 (gnd! 32 41 gnd!) nmos1 w=1.6e-06 l=1.8e-07 as=8.64e-13 ad=8.64e-13 \
        ps=2.68e-06 pd=2.68e-06 m=(1)*(1)
\+23 (gnd! 44 29 gnd!) nmos1 w=1.6e-06 l=1.8e-07 as=8.64e-13 ad=8.64e-13 \
        ps=2.68e-06 pd=2.68e-06 m=(1)*(1)
\+22 (45 37 gnd! gnd!) nmos1 w=1.6e-06 l=1.8e-07 as=8.64e-13 ad=8.64e-13 \
        ps=2.68e-06 pd=2.68e-06 m=(1)*(1)
\+21 (gnd! 40 35 gnd!) nmos1 w=1.6e-06 l=1.8e-07 as=5.04e-13 ad=8.64e-13 \
        ps=6.3e-07 pd=2.68e-06 m=(1)*(1)
\+20 (gnd! 41 36 gnd!) nmos1 w=1.6e-06 l=1.8e-07 as=5.04e-13 ad=8.64e-13 \
        ps=6.3e-07 pd=2.68e-06 m=(1)*(1)
\+19 (38 29 gnd! gnd!) nmos1 w=1.6e-06 l=1.8e-07 as=8.64e-13 ad=8.64e-13 \
        ps=2.68e-06 pd=2.68e-06 m=(1)*(1)
\+18 (39 30 gnd! gnd!) nmos1 w=1.6e-06 l=1.8e-07 as=8.64e-13 ad=8.64e-13 \
        ps=2.68e-06 pd=2.68e-06 m=(1)*(1)
\+17 (37 22 gnd! gnd!) nmos1 w=1.6e-06 l=1.8e-07 as=8.64e-13 ad=8.64e-13 \
        ps=2.68e-06 pd=2.68e-06 m=(1)*(1)
\+16 (35 38 27 gnd!) nmos1 w=1.6e-06 l=1.8e-07 as=8.64e-13 ad=5.04e-13 \
        ps=2.68e-06 pd=6.3e-07 m=(1)*(1)
\+15 (36 39 28 gnd!) nmos1 w=1.6e-06 l=1.8e-07 as=8.64e-13 ad=5.04e-13 \
        ps=2.68e-06 pd=6.3e-07 m=(1)*(1)
\+14 (Z0 21 gnd! gnd!) nmos1 w=1.6e-06 l=1.8e-07 as=8.64e-13 ad=8.64e-13 \
        ps=2.68e-06 pd=2.68e-06 m=(1)*(1)
\+13 (32 20 gnd! gnd!) nmos1 w=1.6e-06 l=1.8e-07 as=8.64e-13 ad=8.64e-13 \
        ps=2.68e-06 pd=2.68e-06 m=(1)*(1)
\+12 (31 19 gnd! gnd!) nmos1 w=1.6e-06 l=1.8e-07 as=8.64e-13 ad=8.64e-13 \
        ps=2.68e-06 pd=2.68e-06 m=(1)*(1)
\+9 (27 29 25 gnd!) nmos1 w=1.6e-06 l=1.8e-07 as=5e-13 ad=8.64e-13 \
        ps=6.25e-07 pd=2.68e-06 m=(1)*(1)
\+8 (28 30 26 gnd!) nmos1 w=1.6e-06 l=1.8e-07 as=5e-13 ad=8.64e-13 \
        ps=6.25e-07 pd=2.68e-06 m=(1)*(1)
\+5 (25 31 gnd! gnd!) nmos1 w=1.6e-06 l=1.8e-07 as=8.72e-13 ad=5e-13 \
        ps=2.69e-06 pd=6.25e-07 m=(1)*(1)
\+4 (26 32 gnd! gnd!) nmos1 w=1.6e-06 l=1.8e-07 as=8.72e-13 ad=5e-13 \
        ps=2.69e-06 pd=6.25e-07 m=(1)*(1)
simulatorOptions options reltol=1e-3 vabstol=1e-6 iabstol=1e-12 temp=27 \
    tnom=27 scalem=1.0 scale=1.0 gmin=1e-12 rforce=1 maxnotes=5 maxwarns=5 \
    digits=5 cols=80 pivrel=1e-3 sensfile="../psf/sens.output" \
    checklimitdest=psf
tran tran stop=30n write="spectre.ic" writefinal="spectre.fc" \
    annotate=status maxiters=5
finalTimeOP info what=oppoint where=rawfile
modelParameter info what=models where=rawfile
element info what=inst where=rawfile
outputParameter info what=output where=rawfile
designParamVals info what=parameters where=rawfile
primitives info what=primitives where=rawfile
subckts info what=subckts  where=rawfile
saveOptions options save=allpub
